// RNL cell RISCA_JL/LB_RES50
// @RNL(type="header") {
//   @VERSION("0.4");
//   @USE-PACKAGE(name="rnl-std-all", version="0.4");
//   @USE-PACKAGE(name="rnl-std-fill") {};
//   @USE-PACKAGE(name="eda-symbol", version="0.2", path="eda-symbol.rnl");
//   @USE-PACKAGE(name="eda-style", version="0.2", path="eda-style.rnl");
//   @DEVICE(model="rm*w", terminals=["p", "n"], type="r")
// }
subckt LB_RES50 A B
R14 (net6 net11 ) rmxw l=25.0u w=2u multi=(1)

R12 (net11 B ) rmxw l=25.0u w=2u multi=(1)

R5 (net6 net4 ) rmxw l=25.0u w=2u multi=(1)

R4 (net4 net3 ) rmxw l=25.0u w=2u multi=(1)

R3 (net3 net5 ) rmxw l=25.0u w=2u multi=(1)

R2 (net1 net5 ) rmxw l=25.0u w=2u multi=(1)

R1 (net2 net1 ) rmxw l=25.0u w=2u multi=(1)

R0 (A net2 ) rmxw l=25.0u w=2u multi=(1)

// @RNL(author="rnl-virtuoso") {
//   %symbol_0 = @DEFINE-SYMBOL(box=[-2, -6, 2, 0]) {
//     @LINE {(0, -6) (0, -4.8) (-1, -4.5) (1, -3.9) (-1, -3.3) (1, -2.7) (-1, -2.1) (1, -1.5) (0, -1.2) (0, 0)};
//     ? @TEXT("${name}", size=0.8, halign="start", valign="baseline", key="name") => @PLACE(1.4, 0.5);
//     ? @TEXT("${model}", size=0.8, halign="end", valign="baseline", key="model") => @PLACE(-1, 0.3);
//     (0, -6) @PIN(terminal=2);
//     (0, 0) @PIN(terminal=1)
//   };
//   #"R4" @SET-SYMBOL %symbol_0;
//   #"R4" @PLACE(0, -1) => @ORIENT("R0");
//   #"R14" @SET-SYMBOL %symbol_0;
//   #"R14" @PLACE(8, -7) => @ORIENT("R180");
//   #"R2" @SET-SYMBOL %symbol_0;
//   #"R2" @PLACE(-8, -7) => @ORIENT("R180");
//   #"R0" @SET-SYMBOL %symbol_0;
//   #"R0" @PLACE(-16, -7) => @ORIENT("R180");
//   #"R5" @SET-SYMBOL %symbol_0;
//   #"R5" @PLACE(4, -7) => @ORIENT("R180");
//   #"R1" @SET-SYMBOL %symbol_0;
//   #"R1" @PLACE(-12, -1) => @ORIENT("R0");
//   #"R3" @SET-SYMBOL %symbol_0;
//   #"R3" @PLACE(-4, -7) => @ORIENT("R180");
//   #"R12" @SET-SYMBOL %symbol_0;
//   #"R12" @PLACE(12, -1) => @ORIENT("R0");
//   %port_0 = $IO_PORT @ATTACH &"A" => @PLACE(-22, -7) => @ORIENT("R0");
//   %port_1 = $IO_PORT @ATTACH &"B" => @PLACE(17, -7) => @ORIENT("MY");
//   %wire_0 = &"net11" @WIRE(mode="straight") {#"R14":2 #"R12":1};
//   %wire_1 = &"net6" @WIRE(mode="straight") {#"R5":1 #"R14":1};
//   %wire_2 = &"net5" @WIRE(mode="straight") {#"R2":2 #"R3":2};
//   %wire_3 = &"net4" @WIRE(mode="straight") {#"R4":1 #"R5":2};
//   %wire_4 = &"net3" @WIRE(mode="straight") {#"R3":1 #"R4":2};
//   %wire_5 = &"net2" @WIRE(mode="straight") {#"R0":2 #"R1":1};
//   %wire_6 = &"net1" @WIRE(mode="straight") {#"R1":2 #"R2":1};
//   %p0 = (16, -7);
//   %wire_7 = &"B" @WIRE(mode="straight") {#"R12":2 %p0};
//   %p1 = (18, -7);
//   %wire_8 = &"B" @WIRE(mode="straight") {%p0 %port_1::pin %p1};
//   %wire_9 = &"A" @WIRE(mode="straight") {%port_0::pin #"R0":1}
// }
ends LB_RES50
