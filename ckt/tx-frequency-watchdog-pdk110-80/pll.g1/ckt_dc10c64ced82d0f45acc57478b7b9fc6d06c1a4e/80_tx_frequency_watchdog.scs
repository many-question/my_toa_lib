simulator lang=spectre
// @RNL(type="header") { @USE-PACKAGE(name="rnl-std-all", version="0.4"); @USE-PACKAGE(name="rnl-std-semantics", version="0.4");
//   @VERSION("0.4");
//   @USE-PACKAGE(name="pll-semantics/tx_frequency_watchdog_pdk110_80", version="0.3", path="pll_semantics.rnl");
//   @USE-PACKAGE(name="pll-inv-pdk110-7-sym", version="0.1");
//   @USE-PACKAGE(name="tx-and-pdk110-47-sym", version="0.1");
//   @USE-PACKAGE(name="tx-dff-r0-pdk110-58-sym", version="0.1");
//   @USE-PACKAGE(name="tx-dff-r1-pdk110-70-sym", version="0.1");
//   @USE-PACKAGE(name="tx-mux-pdk110-64-sym", version="0.1");
//   @USE-PACKAGE(name="tx-or-pdk110-67-sym", version="0.1");
//   @USE-PACKAGE(name="tx-xor-pdk110-66-sym", version="0.1")
// }
// @RNL { # @SELECT-PIN(recursive=true) => @REMOVE-FROM $LABEL_FILL_SET; $SUPPLY_NET_SET @REMOVE-FROM $PORT_FILL_SET; $GROUND_NET_SET @REMOVE-FROM $PORT_FILL_SET }
subckt tx_frequency_watchdog_pdk110_80 (refclk reset active target_k0 target_k1 target_k2 target_k3 target_k4 target_k5 measured0 measured1 measured2 measured3 measured4 measured5 measured6 measured7 measured8 measured9 measured10 measured11 measured12 measured13 count_gate count_reset frequency_good valid vdd vss)
X0 (n29 refclk reset count_reset vdd vss) tx_dff_r1_pdk110_70
X1 (n30 refclk reset count_gate vdd vss) tx_dff_r0_pdk110_58
X2 (n31 refclk reset frequency_good vdd vss) tx_dff_r0_pdk110_58
X3 (n32 refclk reset valid vdd vss) tx_dff_r0_pdk110_58
X4 (n33 refclk reset n34 vdd vss) tx_dff_r0_pdk110_58
X5 (n35 refclk reset n36 vdd vss) tx_dff_r0_pdk110_58
X6 (n37 refclk reset n38 vdd vss) tx_dff_r0_pdk110_58
X7 (n39 refclk reset n40 vdd vss) tx_dff_r0_pdk110_58
X8 (n41 refclk reset n42 vdd vss) tx_dff_r0_pdk110_58
X9 (n43 refclk reset n44 vdd vss) tx_dff_r0_pdk110_58
X10 (n45 refclk reset n46 vdd vss) tx_dff_r0_pdk110_58
X11 (n47 refclk reset n48 vdd vss) tx_dff_r0_pdk110_58
X12 (count_reset n49 n50 n29 vdd vss) tx_mux_pdk110_64
X13 (count_gate n51 n52 n30 vdd vss) tx_mux_pdk110_64
X14 (frequency_good n53 n54 n31 vdd vss) tx_mux_pdk110_64
X15 (measured1 n55 vdd vss) pll_inv_pdk110_7
X16 (measured4 n56 vdd vss) pll_inv_pdk110_7
X17 (measured3 n57 vdd vss) pll_inv_pdk110_7
X18 (measured2 n58 vdd vss) pll_inv_pdk110_7
X19 (measured11 n59 vdd vss) pll_inv_pdk110_7
X20 (measured13 n60 vdd vss) pll_inv_pdk110_7
X21 (measured12 n61 vdd vss) pll_inv_pdk110_7
X22 (n62 n63 vdd vss) pll_inv_pdk110_7
X23 (n64 n65 vdd vss) pll_inv_pdk110_7
X24 (n66 n67 vdd vss) pll_inv_pdk110_7
X25 (n68 n69 vdd vss) pll_inv_pdk110_7
X26 (n70 n71 vdd vss) pll_inv_pdk110_7
X27 (n72 n73 vdd vss) pll_inv_pdk110_7
X28 (n74 n75 vdd vss) pll_inv_pdk110_7
X29 (target_k1 n76 vdd vss) pll_inv_pdk110_7
X30 (target_k0 n77 vdd vss) pll_inv_pdk110_7
X31 (active n78 vdd vss) pll_inv_pdk110_7
X32 (n79 n80 vdd vss) pll_inv_pdk110_7
X33 (n81 n82 vdd vss) pll_inv_pdk110_7
X34 (n38 n83 n84 vdd vss) tx_and_pdk110_47
X35 (n42 n85 n86 vdd vss) tx_and_pdk110_47
X36 (n87 n85 n88 vdd vss) tx_and_pdk110_47
X37 (n46 n88 n89 vdd vss) tx_and_pdk110_47
X38 (n90 n83 n85 vdd vss) tx_and_pdk110_47
X39 (n44 n42 n87 vdd vss) tx_and_pdk110_47
X40 (n40 n38 n90 vdd vss) tx_and_pdk110_47
X41 (n36 n34 n83 vdd vss) tx_and_pdk110_47
X42 (n91 n92 n81 vdd vss) tx_or_pdk110_67
X43 (n93 n94 n92 vdd vss) tx_and_pdk110_47
X44 (n95 n96 n94 vdd vss) tx_or_pdk110_67
X45 (n97 n98 n96 vdd vss) tx_and_pdk110_47
X46 (n99 n100 n93 vdd vss) tx_and_pdk110_47
X47 (target_k5 n101 n91 vdd vss) tx_or_pdk110_67
X48 (n99 target_k4 n101 vdd vss) tx_and_pdk110_47
X49 (n102 n94 n103 vdd vss) tx_and_pdk110_47
X50 (n104 n103 n79 vdd vss) tx_or_pdk110_67
X51 (target_k5 target_k4 n104 vdd vss) tx_and_pdk110_47
X52 (target_k3 target_k2 n95 vdd vss) tx_and_pdk110_47
X53 (target_k1 n105 n98 vdd vss) tx_or_pdk110_67
X54 (n76 target_k0 n105 vdd vss) tx_and_pdk110_47
X55 (measured4 n106 n107 vdd vss) tx_and_pdk110_47
X56 (measured2 n108 n109 vdd vss) tx_and_pdk110_47
X57 (measured10 n110 n111 vdd vss) tx_and_pdk110_47
X58 (n112 n113 n110 vdd vss) tx_and_pdk110_47
X59 (n114 n106 n115 vdd vss) tx_and_pdk110_47
X60 (measured6 n115 n116 vdd vss) tx_and_pdk110_47
X61 (n117 n113 n118 vdd vss) tx_and_pdk110_47
X62 (measured12 n118 n119 vdd vss) tx_and_pdk110_47
X63 (n120 n106 n113 vdd vss) tx_and_pdk110_47
X64 (n121 n112 n117 vdd vss) tx_and_pdk110_47
X65 (n122 n114 n120 vdd vss) tx_and_pdk110_47
X66 (n123 n108 n106 vdd vss) tx_and_pdk110_47
X67 (measured11 measured10 n121 vdd vss) tx_and_pdk110_47
X68 (measured9 measured8 n112 vdd vss) tx_and_pdk110_47
X69 (measured7 measured6 n122 vdd vss) tx_and_pdk110_47
X70 (measured5 measured4 n114 vdd vss) tx_and_pdk110_47
X71 (measured3 measured2 n123 vdd vss) tx_and_pdk110_47
X72 (measured8 n113 n124 vdd vss) tx_and_pdk110_47
X73 (measured1 measured0 n108 vdd vss) tx_and_pdk110_47
X74 (n125 n77 n126 vdd vss) tx_and_pdk110_47
X75 (n127 n76 n128 vdd vss) tx_and_pdk110_47
X76 (n129 n130 n131 vdd vss) tx_and_pdk110_47
X77 (n132 n133 n134 vdd vss) tx_and_pdk110_47
X78 (n135 n100 n136 vdd vss) tx_and_pdk110_47
X79 (n137 n99 n138 vdd vss) tx_and_pdk110_47
X80 (n125 n77 n139 vdd vss) tx_xor_pdk110_66
X81 (n127 n76 n140 vdd vss) tx_xor_pdk110_66
X82 (n129 n130 n141 vdd vss) tx_xor_pdk110_66
X83 (n132 n133 n142 vdd vss) tx_xor_pdk110_66
X84 (n135 n100 n143 vdd vss) tx_xor_pdk110_66
X85 (n137 n99 n144 vdd vss) tx_xor_pdk110_66
X86 (n145 n146 n147 vdd vss) tx_or_pdk110_67
X87 (n148 n149 n146 vdd vss) tx_and_pdk110_47
X88 (n150 n151 n149 vdd vss) tx_or_pdk110_67
X89 (n152 n153 n151 vdd vss) tx_and_pdk110_47
X90 (n154 n155 n153 vdd vss) tx_or_pdk110_67
X91 (n156 n157 n155 vdd vss) tx_and_pdk110_47
X92 (n158 n159 n150 vdd vss) tx_or_pdk110_67
X93 (n160 n161 n159 vdd vss) tx_and_pdk110_47
X94 (n162 n163 n154 vdd vss) tx_or_pdk110_67
X95 (n164 n165 n163 vdd vss) tx_and_pdk110_47
X96 (n166 n167 n157 vdd vss) tx_or_pdk110_67
X97 (n72 n168 n145 vdd vss) tx_or_pdk110_67
X98 (n73 n74 n168 vdd vss) tx_and_pdk110_47
X99 (n71 n144 n160 vdd vss) tx_and_pdk110_47
X100 (n70 n169 n158 vdd vss) tx_or_pdk110_67
X101 (n71 n138 n169 vdd vss) tx_and_pdk110_47
X102 (n143 n142 n170 vdd vss) tx_and_pdk110_47
X103 (n136 n171 n161 vdd vss) tx_or_pdk110_67
X104 (n143 n134 n171 vdd vss) tx_and_pdk110_47
X105 (n131 n172 n162 vdd vss) tx_or_pdk110_67
X106 (n141 n128 n172 vdd vss) tx_and_pdk110_47
X107 (n126 n173 n165 vdd vss) tx_or_pdk110_67
X108 (n139 n64 n173 vdd vss) tx_and_pdk110_47
X109 (n67 n69 n167 vdd vss) tx_and_pdk110_47
X110 (n66 n174 n166 vdd vss) tx_or_pdk110_67
X111 (n67 n68 n174 vdd vss) tx_and_pdk110_47
X112 (measured5 n77 n175 vdd vss) tx_and_pdk110_47
X113 (measured6 n76 n176 vdd vss) tx_and_pdk110_47
X114 (measured7 n130 n177 vdd vss) tx_and_pdk110_47
X115 (measured8 n133 n178 vdd vss) tx_and_pdk110_47
X116 (measured9 n100 n179 vdd vss) tx_and_pdk110_47
X117 (measured10 n99 n180 vdd vss) tx_and_pdk110_47
X118 (measured5 n77 n181 vdd vss) tx_xor_pdk110_66
X119 (measured6 n76 n182 vdd vss) tx_xor_pdk110_66
X120 (measured7 n130 n183 vdd vss) tx_xor_pdk110_66
X121 (measured8 n133 n184 vdd vss) tx_xor_pdk110_66
X122 (measured9 n100 n185 vdd vss) tx_xor_pdk110_66
X123 (measured10 n99 n186 vdd vss) tx_xor_pdk110_66
X124 (n187 n188 n189 vdd vss) tx_or_pdk110_67
X125 (n190 n191 n188 vdd vss) tx_and_pdk110_47
X126 (n192 n193 n191 vdd vss) tx_or_pdk110_67
X127 (n194 n195 n193 vdd vss) tx_and_pdk110_47
X128 (n196 n197 n195 vdd vss) tx_or_pdk110_67
X129 (n198 n199 n197 vdd vss) tx_and_pdk110_47
X130 (n200 n201 n192 vdd vss) tx_or_pdk110_67
X131 (n202 n203 n201 vdd vss) tx_and_pdk110_47
X132 (n204 n205 n196 vdd vss) tx_or_pdk110_67
X133 (n206 n207 n205 vdd vss) tx_and_pdk110_47
X134 (n208 n209 n199 vdd vss) tx_or_pdk110_67
X135 (n210 n211 n209 vdd vss) tx_and_pdk110_47
X136 (measured13 n212 n187 vdd vss) tx_or_pdk110_67
X137 (n60 measured12 n212 vdd vss) tx_and_pdk110_47
X138 (measured11 n213 n200 vdd vss) tx_or_pdk110_67
X139 (n59 n180 n213 vdd vss) tx_and_pdk110_47
X140 (n185 n184 n214 vdd vss) tx_and_pdk110_47
X141 (n179 n215 n203 vdd vss) tx_or_pdk110_67
X142 (n185 n178 n215 vdd vss) tx_and_pdk110_47
X143 (n183 n182 n206 vdd vss) tx_and_pdk110_47
X144 (n177 n216 n204 vdd vss) tx_or_pdk110_67
X145 (n183 n176 n216 vdd vss) tx_and_pdk110_47
X146 (n181 n56 n217 vdd vss) tx_and_pdk110_47
X147 (n175 n218 n207 vdd vss) tx_or_pdk110_67
X148 (n181 measured4 n218 vdd vss) tx_and_pdk110_47
X149 (measured3 n219 n208 vdd vss) tx_or_pdk110_67
X150 (n57 measured2 n219 vdd vss) tx_and_pdk110_47
X151 (measured1 n220 n211 vdd vss) tx_or_pdk110_67
X152 (n55 measured0 n220 vdd vss) tx_and_pdk110_47
X153 (n82 n221 n222 vdd vss) tx_or_pdk110_67
X154 (n223 n224 n225 vdd vss) tx_or_pdk110_67
X155 (n36 n34 n226 vdd vss) tx_xor_pdk110_66
X156 (n38 n83 n227 vdd vss) tx_xor_pdk110_66
X157 (n40 n84 n228 vdd vss) tx_xor_pdk110_66
X158 (n42 n85 n229 vdd vss) tx_xor_pdk110_66
X159 (n44 n86 n230 vdd vss) tx_xor_pdk110_66
X160 (n46 n88 n231 vdd vss) tx_xor_pdk110_66
X161 (n48 n89 n232 vdd vss) tx_xor_pdk110_66
X162 (measured1 measured0 n62 vdd vss) tx_xor_pdk110_66
X163 (measured2 n108 n68 vdd vss) tx_xor_pdk110_66
X164 (measured3 n109 n66 vdd vss) tx_xor_pdk110_66
X165 (measured4 n106 n64 vdd vss) tx_xor_pdk110_66
X166 (measured5 n107 n125 vdd vss) tx_xor_pdk110_66
X167 (measured6 n115 n127 vdd vss) tx_xor_pdk110_66
X168 (measured7 n116 n129 vdd vss) tx_xor_pdk110_66
X169 (measured8 n113 n132 vdd vss) tx_xor_pdk110_66
X170 (measured9 n124 n135 vdd vss) tx_xor_pdk110_66
X171 (measured10 n110 n137 vdd vss) tx_xor_pdk110_66
X172 (measured11 n111 n70 vdd vss) tx_xor_pdk110_66
X173 (measured12 n118 n74 vdd vss) tx_xor_pdk110_66
X174 (measured13 n119 n72 vdd vss) tx_xor_pdk110_66
X175 (n78 n233 n234 vdd vss) tx_or_pdk110_67
X176 (n234 n235 n50 vdd vss) tx_or_pdk110_67
X177 (n78 n236 n237 vdd vss) tx_or_pdk110_67
X178 (n237 n238 n52 vdd vss) tx_or_pdk110_67
X179 (n78 n239 n54 vdd vss) tx_or_pdk110_67
X180 (n240 n36 n241 vdd vss) tx_or_pdk110_67
X181 (n241 n242 n243 vdd vss) tx_or_pdk110_67
X182 (n243 n244 n245 vdd vss) tx_or_pdk110_67
X183 (n246 n40 n242 vdd vss) tx_or_pdk110_67
X184 (n247 n242 n248 vdd vss) tx_or_pdk110_67
X185 (n248 n244 n249 vdd vss) tx_or_pdk110_67
X186 (n42 n250 n251 vdd vss) tx_or_pdk110_67
X187 (n251 n252 n244 vdd vss) tx_or_pdk110_67
X188 (n253 n244 n254 vdd vss) tx_or_pdk110_67
X189 (n34 n255 n247 vdd vss) tx_or_pdk110_67
X190 (n38 n40 n256 vdd vss) tx_or_pdk110_67
X191 (n42 n44 n257 vdd vss) tx_or_pdk110_67
X192 (n46 n48 n252 vdd vss) tx_or_pdk110_67
X193 (n247 n256 n253 vdd vss) tx_or_pdk110_67
X194 (n257 n252 n258 vdd vss) tx_or_pdk110_67
X195 (n253 n258 n259 vdd vss) tx_or_pdk110_67
X196 (n260 n93 n221 vdd vss) tx_and_pdk110_47
X197 (n261 n221 n262 vdd vss) tx_or_pdk110_67
X198 (n130 target_k3 n97 vdd vss) tx_and_pdk110_47
X199 (n100 target_k5 n102 vdd vss) tx_and_pdk110_47
X200 (n105 n97 n260 vdd vss) tx_and_pdk110_47
X201 (n260 n102 n263 vdd vss) tx_and_pdk110_47
X202 (n80 n263 n264 vdd vss) tx_or_pdk110_67
X203 (measured0 n63 n265 vdd vss) tx_and_pdk110_47
X204 (n65 n139 n266 vdd vss) tx_and_pdk110_47
X205 (n140 n141 n164 vdd vss) tx_and_pdk110_47
X206 (n75 n73 n148 vdd vss) tx_and_pdk110_47
X207 (n265 n167 n267 vdd vss) tx_and_pdk110_47
X208 (n266 n164 n156 vdd vss) tx_and_pdk110_47
X209 (n170 n160 n152 vdd vss) tx_and_pdk110_47
X210 (n267 n156 n268 vdd vss) tx_and_pdk110_47
X211 (n152 n148 n269 vdd vss) tx_and_pdk110_47
X212 (n268 n269 n224 vdd vss) tx_and_pdk110_47
X213 (n270 n224 n271 vdd vss) tx_or_pdk110_67
X214 (n58 n57 n210 vdd vss) tx_and_pdk110_47
X215 (n186 n59 n202 vdd vss) tx_and_pdk110_47
X216 (n61 n60 n190 vdd vss) tx_and_pdk110_47
X217 (n220 n210 n272 vdd vss) tx_and_pdk110_47
X218 (n217 n206 n198 vdd vss) tx_and_pdk110_47
X219 (n214 n202 n194 vdd vss) tx_and_pdk110_47
X220 (n272 n198 n273 vdd vss) tx_and_pdk110_47
X221 (n194 n190 n274 vdd vss) tx_and_pdk110_47
X222 (n273 n274 n275 vdd vss) tx_and_pdk110_47
X223 (n276 n275 n277 vdd vss) tx_or_pdk110_67
X224 (n233 n235 n278 vdd vss) tx_or_pdk110_67
X225 (n34 n36 n279 vdd vss) tx_or_pdk110_67
X226 (n279 n256 n280 vdd vss) tx_or_pdk110_67
X227 (n280 n258 n281 vdd vss) tx_or_pdk110_67
X228 (n236 n238 n282 vdd vss) tx_or_pdk110_67
X229 (n245 n239 vdd vss) pll_inv_pdk110_7
X230 (n249 n233 vdd vss) pll_inv_pdk110_7
X231 (n281 n235 vdd vss) pll_inv_pdk110_7
X232 (n254 n236 vdd vss) pll_inv_pdk110_7
X233 (n259 n238 vdd vss) pll_inv_pdk110_7
X234 (n262 n264 n283 vdd vss) tx_and_pdk110_47
X235 (n283 n271 n284 vdd vss) tx_and_pdk110_47
X236 (n284 n277 n285 vdd vss) tx_and_pdk110_47
X237 (vss n239 active n32 vdd vss) tx_mux_pdk110_64
X238 (vss n240 active n33 vdd vss) tx_mux_pdk110_64
X239 (vss n226 active n35 vdd vss) tx_mux_pdk110_64
X240 (vss n227 active n37 vdd vss) tx_mux_pdk110_64
X241 (vss n228 active n39 vdd vss) tx_mux_pdk110_64
X242 (vss n229 active n41 vdd vss) tx_mux_pdk110_64
X243 (vss n230 active n43 vdd vss) tx_mux_pdk110_64
X244 (vss n231 active n45 vdd vss) tx_mux_pdk110_64
X245 (vss n232 active n47 vdd vss) tx_mux_pdk110_64
X246 (n285 nx n245 n286 vdd vss) tx_mux_pdk110_64
X247 (vss n286 active n53 vdd vss) tx_mux_pdk110_64
X248 (vdd n287 active n49 vdd vss) tx_mux_pdk110_64
X249 (vss n288 active n51 vdd vss) tx_mux_pdk110_64
X250 (target_k2 n130 vdd vss) pll_inv_pdk110_7
X251 (target_k3 n133 vdd vss) pll_inv_pdk110_7
X252 (target_k4 n100 vdd vss) pll_inv_pdk110_7
X253 (target_k5 n99 vdd vss) pll_inv_pdk110_7
X254 (n222 n261 vdd vss) pll_inv_pdk110_7
X255 (n225 n270 vdd vss) pll_inv_pdk110_7
X256 (n147 n223 vdd vss) pll_inv_pdk110_7
X257 (n189 n276 vdd vss) pll_inv_pdk110_7
X258 (n34 n240 vdd vss) pll_inv_pdk110_7
X259 (n36 n255 vdd vss) pll_inv_pdk110_7
X260 (n38 n246 vdd vss) pll_inv_pdk110_7
X261 (n44 n250 vdd vss) pll_inv_pdk110_7
X262 (nx n233 n278 n287 vdd vss) tx_mux_pdk110_64
X263 (nx n238 n282 n288 vdd vss) tx_mux_pdk110_64
// @RNL(author="gemini-4-argon") {
//
//   /* --- 1. Circuit Semantics --- */
//   %fsm = {#X0 #X1 #X2 #X3 #X4 #X5 #X6 #X7 #X8 #X9 #X10 #X11}(state_ffs) {#X12 #X13 #X14 #X237 #X238 #X239 #X240 #X241 #X242 #X243 #X244 #X245 #X246 #X247 #X248 #X249 #X262 #X263}(datapath_muxes) {#X15 #X16 #X17 #X18 #X19 #X20 #X21 #X22 #X23 #X24 #X25 #X26 #X27 #X28 #X29 #X30 #X31 #X32 #X33 #X34 #X35 #X36 #X37 #X38 #X39 #X40 #X41 #X42 #X43 #X44 #X45 #X46 #X47 #X48 #X49 #X50 #X51 #X52 #X53 #X54 #X55 #X56 #X57 #X58 #X59 #X60 #X61 #X62 #X63 #X64 #X65 #X66 #X67 #X68 #X69 #X70 #X71 #X72 #X73 #X74 #X75 #X76 #X77 #X78 #X79 #X80 #X81 #X82 #X83 #X84 #X85 #X86 #X87 #X88 #X89 #X90 #X91 #X92 #X93 #X94 #X95 #X96 #X97 #X98 #X99 #X100 #X101 #X102 #X103 #X104 #X105 #X106 #X107 #X108 #X109 #X110 #X111 #X112 #X113 #X114 #X115 #X116 #X117 #X118 #X119 #X120 #X121 #X122 #X123 #X124 #X125 #X126 #X127 #X128 #X129 #X130 #X131 #X132 #X133 #X134 #X135 #X136 #X137 #X138 #X139 #X140 #X141 #X142 #X143 #X144 #X145 #X146 #X147 #X148 #X149 #X150 #X151 #X152 #X153 #X154 #X155 #X156 #X157 #X158 #X159 #X160 #X161 #X162 #X163 #X164 #X165 #X166 #X167 #X168 #X169 #X170 #X171 #X172 #X173 #X174 #X175 #X176 #X177 #X178 #X179 #X180 #X181 #X182 #X183 #X184 #X185 #X186 #X187 #X188 #X189 #X190 #X191 #X192 #X193 #X194 #X195 #X196 #X197 #X198 #X199 #X200 #X201 #X202 #X203 #X204 #X205 #X206 #X207 #X208 #X209 #X210 #X211 #X212 #X213 #X214 #X215 #X216 #X217 #X218 #X219 #X220 #X221 #X222 #X223 #X224 #X225 #X226 #X227 #X228 #X229 #X230 #X231 #X232 #X233 #X234 #X235 #X236 #X250 #X251 #X252 #X253 #X254 #X255 #X256 #X257 #X258 #X259 #X260 #X261}(comb_logic) @AS(controller_name="80_tx_frequency_watchdog", clock_domain="refclk") $SYNTHESIZED_FSM_CONTROLLER;
//   {%p_refclk #X0 #X12 #X15 %p_count_gate} @AS $SIGNAL_FLOW; {%p_refclk #X0 #X12 #X15 %p_count_gate} @ORDER("left-to-right", priority="low");
//   %defect_nx = {#X246 #X262 #X263}(culprit_devices) {&nx}(affected_nets) @AS(
//     severity="critical",
//     category="undriven_floating_net_nx_from_synthesis_tie_cell_omission",
//     mechanism="Net 'nx' has zero drivers in tx_frequency_watchdog_pdk110_80; synthesis hi/lo tie emission bug leaves mux input a floating (tie nx to vss/vdd)",
//     recommendation="Tie net nx to vss (or appropriate constant tie cell) in the synthesized netlist"
//   ) $DESIGN_DEFECT;
//
//   /* --- 2. Structured Column Placement & Orientation --- */
//   {&target_k1 &target_k2 &target_k3 &target_k4 &target_k5 &measured1 &measured2 &measured3 &measured4 &measured5 &measured6 &measured7 &measured8 &measured9 &measured10 &measured11 &measured12 &measured13} @REMOVE-FROM $PORT_FILL_SET;
//   %p_refclk = $IO_PORT @ATTACH &refclk => @PLACE(2, 127) => @ORIENT("R0");
//   %p_reset = $IO_PORT @ATTACH &reset => @PLACE(2, 102) => @ORIENT("R0");
//   %p_active = $IO_PORT @ATTACH &active => @PLACE(2, 77) => @ORIENT("R0");
//   %p_target_k0 = $IO_PORT @ATTACH &target_k0 => @PLACE(2, 52) => @ORIENT("R0");
//   %p_target_k0 @TEXT("target_k<5:0>", key="netname");
//   %p_measured0 = $IO_PORT @ATTACH &measured0 => @PLACE(2, 27) => @ORIENT("R0");
//   %p_measured0 @TEXT("measured<13:0>", key="netname");
//   %p_count_gate = $IO_PORT @ATTACH &count_gate => @PLACE(284, 122) => @ORIENT("MY");
//   %p_count_reset = $IO_PORT @ATTACH &count_reset => @PLACE(284, 92) => @ORIENT("MY");
//   %p_frequency_good = $IO_PORT @ATTACH &frequency_good => @PLACE(284, 62) => @ORIENT("MY");
//   %p_valid = $IO_PORT @ATTACH &valid => @PLACE(284, 32) => @ORIENT("MY");
//   #X0 @PLACE(24, 144) => @ORIENT("R0");
//   #X1 @PLACE(24, 136) => @ORIENT("R0");
//   #X2 @PLACE(24, 128) => @ORIENT("R0");
//   #X3 @PLACE(24, 120) => @ORIENT("R0");
//   #X4 @PLACE(24, 112) => @ORIENT("R0");
//   #X5 @PLACE(24, 104) => @ORIENT("R0");
//   #X6 @PLACE(24, 96) => @ORIENT("R0");
//   #X7 @PLACE(24, 88) => @ORIENT("R0");
//   #X8 @PLACE(24, 80) => @ORIENT("R0");
//   #X9 @PLACE(24, 72) => @ORIENT("R0");
//   #X10 @PLACE(24, 64) => @ORIENT("R0");
//   #X11 @PLACE(24, 56) => @ORIENT("R0");
//   #X12 @PLACE(48, 144) => @ORIENT("R0");
//   #X13 @PLACE(48, 136) => @ORIENT("R0");
//   #X14 @PLACE(48, 128) => @ORIENT("R0");
//   #X237 @PLACE(48, 120) => @ORIENT("R0");
//   #X238 @PLACE(48, 112) => @ORIENT("R0");
//   #X239 @PLACE(48, 104) => @ORIENT("R0");
//   #X240 @PLACE(48, 96) => @ORIENT("R0");
//   #X241 @PLACE(48, 88) => @ORIENT("R0");
//   #X242 @PLACE(48, 80) => @ORIENT("R0");
//   #X243 @PLACE(48, 72) => @ORIENT("R0");
//   #X244 @PLACE(48, 64) => @ORIENT("R0");
//   #X245 @PLACE(48, 56) => @ORIENT("R0");
//   #X246 @PLACE(48, 48) => @ORIENT("R0");
//   #X247 @PLACE(48, 40) => @ORIENT("R0");
//   #X248 @PLACE(48, 32) => @ORIENT("R0");
//   #X249 @PLACE(48, 24) => @ORIENT("R0");
//   #X262 @PLACE(48, 16) => @ORIENT("R0");
//   #X263 @PLACE(48, 8) => @ORIENT("R0");
//   #X15 @PLACE(72, 144) => @ORIENT("R0");
//   #X16 @PLACE(72, 136) => @ORIENT("R0");
//   #X17 @PLACE(72, 128) => @ORIENT("R0");
//   #X18 @PLACE(72, 120) => @ORIENT("R0");
//   #X19 @PLACE(72, 112) => @ORIENT("R0");
//   #X20 @PLACE(72, 104) => @ORIENT("R0");
//   #X21 @PLACE(72, 96) => @ORIENT("R0");
//   #X22 @PLACE(72, 88) => @ORIENT("R0");
//   #X23 @PLACE(72, 80) => @ORIENT("R0");
//   #X24 @PLACE(72, 72) => @ORIENT("R0");
//   #X25 @PLACE(72, 64) => @ORIENT("R0");
//   #X26 @PLACE(72, 56) => @ORIENT("R0");
//   #X27 @PLACE(72, 48) => @ORIENT("R0");
//   #X28 @PLACE(72, 40) => @ORIENT("R0");
//   #X29 @PLACE(72, 32) => @ORIENT("R0");
//   #X30 @PLACE(72, 24) => @ORIENT("R0");
//   #X31 @PLACE(72, 16) => @ORIENT("R0");
//   #X32 @PLACE(72, 8) => @ORIENT("R0");
//   #X33 @PLACE(88, 144) => @ORIENT("R0");
//   #X34 @PLACE(88, 136) => @ORIENT("R0");
//   #X35 @PLACE(88, 128) => @ORIENT("R0");
//   #X36 @PLACE(88, 120) => @ORIENT("R0");
//   #X37 @PLACE(88, 112) => @ORIENT("R0");
//   #X38 @PLACE(88, 104) => @ORIENT("R0");
//   #X39 @PLACE(88, 96) => @ORIENT("R0");
//   #X40 @PLACE(88, 88) => @ORIENT("R0");
//   #X41 @PLACE(88, 80) => @ORIENT("R0");
//   #X42 @PLACE(88, 72) => @ORIENT("R0");
//   #X43 @PLACE(88, 64) => @ORIENT("R0");
//   #X44 @PLACE(88, 56) => @ORIENT("R0");
//   #X45 @PLACE(88, 48) => @ORIENT("R0");
//   #X46 @PLACE(88, 40) => @ORIENT("R0");
//   #X47 @PLACE(88, 32) => @ORIENT("R0");
//   #X48 @PLACE(88, 24) => @ORIENT("R0");
//   #X49 @PLACE(88, 16) => @ORIENT("R0");
//   #X50 @PLACE(88, 8) => @ORIENT("R0");
//   #X51 @PLACE(104, 144) => @ORIENT("R0");
//   #X52 @PLACE(104, 136) => @ORIENT("R0");
//   #X53 @PLACE(104, 128) => @ORIENT("R0");
//   #X54 @PLACE(104, 120) => @ORIENT("R0");
//   #X55 @PLACE(104, 112) => @ORIENT("R0");
//   #X56 @PLACE(104, 104) => @ORIENT("R0");
//   #X57 @PLACE(104, 96) => @ORIENT("R0");
//   #X58 @PLACE(104, 88) => @ORIENT("R0");
//   #X59 @PLACE(104, 80) => @ORIENT("R0");
//   #X60 @PLACE(104, 72) => @ORIENT("R0");
//   #X61 @PLACE(104, 64) => @ORIENT("R0");
//   #X62 @PLACE(104, 56) => @ORIENT("R0");
//   #X63 @PLACE(104, 48) => @ORIENT("R0");
//   #X64 @PLACE(104, 40) => @ORIENT("R0");
//   #X65 @PLACE(104, 32) => @ORIENT("R0");
//   #X66 @PLACE(104, 24) => @ORIENT("R0");
//   #X67 @PLACE(104, 16) => @ORIENT("R0");
//   #X68 @PLACE(104, 8) => @ORIENT("R0");
//   #X69 @PLACE(120, 144) => @ORIENT("R0");
//   #X70 @PLACE(120, 136) => @ORIENT("R0");
//   #X71 @PLACE(120, 128) => @ORIENT("R0");
//   #X72 @PLACE(120, 120) => @ORIENT("R0");
//   #X73 @PLACE(120, 112) => @ORIENT("R0");
//   #X74 @PLACE(120, 104) => @ORIENT("R0");
//   #X75 @PLACE(120, 96) => @ORIENT("R0");
//   #X76 @PLACE(120, 88) => @ORIENT("R0");
//   #X77 @PLACE(120, 80) => @ORIENT("R0");
//   #X78 @PLACE(120, 72) => @ORIENT("R0");
//   #X79 @PLACE(120, 64) => @ORIENT("R0");
//   #X80 @PLACE(120, 56) => @ORIENT("R0");
//   #X81 @PLACE(120, 48) => @ORIENT("R0");
//   #X82 @PLACE(120, 40) => @ORIENT("R0");
//   #X83 @PLACE(120, 32) => @ORIENT("R0");
//   #X84 @PLACE(120, 24) => @ORIENT("R0");
//   #X85 @PLACE(120, 16) => @ORIENT("R0");
//   #X86 @PLACE(120, 8) => @ORIENT("R0");
//   #X87 @PLACE(136, 144) => @ORIENT("R0");
//   #X88 @PLACE(136, 136) => @ORIENT("R0");
//   #X89 @PLACE(136, 128) => @ORIENT("R0");
//   #X90 @PLACE(136, 120) => @ORIENT("R0");
//   #X91 @PLACE(136, 112) => @ORIENT("R0");
//   #X92 @PLACE(136, 104) => @ORIENT("R0");
//   #X93 @PLACE(136, 96) => @ORIENT("R0");
//   #X94 @PLACE(136, 88) => @ORIENT("R0");
//   #X95 @PLACE(136, 80) => @ORIENT("R0");
//   #X96 @PLACE(136, 72) => @ORIENT("R0");
//   #X97 @PLACE(136, 64) => @ORIENT("R0");
//   #X98 @PLACE(136, 56) => @ORIENT("R0");
//   #X99 @PLACE(136, 48) => @ORIENT("R0");
//   #X100 @PLACE(136, 40) => @ORIENT("R0");
//   #X101 @PLACE(136, 32) => @ORIENT("R0");
//   #X102 @PLACE(136, 24) => @ORIENT("R0");
//   #X103 @PLACE(136, 16) => @ORIENT("R0");
//   #X104 @PLACE(136, 8) => @ORIENT("R0");
//   #X105 @PLACE(152, 144) => @ORIENT("R0");
//   #X106 @PLACE(152, 136) => @ORIENT("R0");
//   #X107 @PLACE(152, 128) => @ORIENT("R0");
//   #X108 @PLACE(152, 120) => @ORIENT("R0");
//   #X109 @PLACE(152, 112) => @ORIENT("R0");
//   #X110 @PLACE(152, 104) => @ORIENT("R0");
//   #X111 @PLACE(152, 96) => @ORIENT("R0");
//   #X112 @PLACE(152, 88) => @ORIENT("R0");
//   #X113 @PLACE(152, 80) => @ORIENT("R0");
//   #X114 @PLACE(152, 72) => @ORIENT("R0");
//   #X115 @PLACE(152, 64) => @ORIENT("R0");
//   #X116 @PLACE(152, 56) => @ORIENT("R0");
//   #X117 @PLACE(152, 48) => @ORIENT("R0");
//   #X118 @PLACE(152, 40) => @ORIENT("R0");
//   #X119 @PLACE(152, 32) => @ORIENT("R0");
//   #X120 @PLACE(152, 24) => @ORIENT("R0");
//   #X121 @PLACE(152, 16) => @ORIENT("R0");
//   #X122 @PLACE(152, 8) => @ORIENT("R0");
//   #X123 @PLACE(168, 144) => @ORIENT("R0");
//   #X124 @PLACE(168, 136) => @ORIENT("R0");
//   #X125 @PLACE(168, 128) => @ORIENT("R0");
//   #X126 @PLACE(168, 120) => @ORIENT("R0");
//   #X127 @PLACE(168, 112) => @ORIENT("R0");
//   #X128 @PLACE(168, 104) => @ORIENT("R0");
//   #X129 @PLACE(168, 96) => @ORIENT("R0");
//   #X130 @PLACE(168, 88) => @ORIENT("R0");
//   #X131 @PLACE(168, 80) => @ORIENT("R0");
//   #X132 @PLACE(168, 72) => @ORIENT("R0");
//   #X133 @PLACE(168, 64) => @ORIENT("R0");
//   #X134 @PLACE(168, 56) => @ORIENT("R0");
//   #X135 @PLACE(168, 48) => @ORIENT("R0");
//   #X136 @PLACE(168, 40) => @ORIENT("R0");
//   #X137 @PLACE(168, 32) => @ORIENT("R0");
//   #X138 @PLACE(168, 24) => @ORIENT("R0");
//   #X139 @PLACE(168, 16) => @ORIENT("R0");
//   #X140 @PLACE(168, 8) => @ORIENT("R0");
//   #X141 @PLACE(184, 144) => @ORIENT("R0");
//   #X142 @PLACE(184, 136) => @ORIENT("R0");
//   #X143 @PLACE(184, 128) => @ORIENT("R0");
//   #X144 @PLACE(184, 120) => @ORIENT("R0");
//   #X145 @PLACE(184, 112) => @ORIENT("R0");
//   #X146 @PLACE(184, 104) => @ORIENT("R0");
//   #X147 @PLACE(184, 96) => @ORIENT("R0");
//   #X148 @PLACE(184, 88) => @ORIENT("R0");
//   #X149 @PLACE(184, 80) => @ORIENT("R0");
//   #X150 @PLACE(184, 72) => @ORIENT("R0");
//   #X151 @PLACE(184, 64) => @ORIENT("R0");
//   #X152 @PLACE(184, 56) => @ORIENT("R0");
//   #X153 @PLACE(184, 48) => @ORIENT("R0");
//   #X154 @PLACE(184, 40) => @ORIENT("R0");
//   #X155 @PLACE(184, 32) => @ORIENT("R0");
//   #X156 @PLACE(184, 24) => @ORIENT("R0");
//   #X157 @PLACE(184, 16) => @ORIENT("R0");
//   #X158 @PLACE(184, 8) => @ORIENT("R0");
//   #X159 @PLACE(200, 144) => @ORIENT("R0");
//   #X160 @PLACE(200, 136) => @ORIENT("R0");
//   #X161 @PLACE(200, 128) => @ORIENT("R0");
//   #X162 @PLACE(200, 120) => @ORIENT("R0");
//   #X163 @PLACE(200, 112) => @ORIENT("R0");
//   #X164 @PLACE(200, 104) => @ORIENT("R0");
//   #X165 @PLACE(200, 96) => @ORIENT("R0");
//   #X166 @PLACE(200, 88) => @ORIENT("R0");
//   #X167 @PLACE(200, 80) => @ORIENT("R0");
//   #X168 @PLACE(200, 72) => @ORIENT("R0");
//   #X169 @PLACE(200, 64) => @ORIENT("R0");
//   #X170 @PLACE(200, 56) => @ORIENT("R0");
//   #X171 @PLACE(200, 48) => @ORIENT("R0");
//   #X172 @PLACE(200, 40) => @ORIENT("R0");
//   #X173 @PLACE(200, 32) => @ORIENT("R0");
//   #X174 @PLACE(200, 24) => @ORIENT("R0");
//   #X175 @PLACE(200, 16) => @ORIENT("R0");
//   #X176 @PLACE(200, 8) => @ORIENT("R0");
//   #X177 @PLACE(216, 144) => @ORIENT("R0");
//   #X178 @PLACE(216, 136) => @ORIENT("R0");
//   #X179 @PLACE(216, 128) => @ORIENT("R0");
//   #X180 @PLACE(216, 120) => @ORIENT("R0");
//   #X181 @PLACE(216, 112) => @ORIENT("R0");
//   #X182 @PLACE(216, 104) => @ORIENT("R0");
//   #X183 @PLACE(216, 96) => @ORIENT("R0");
//   #X184 @PLACE(216, 88) => @ORIENT("R0");
//   #X185 @PLACE(216, 80) => @ORIENT("R0");
//   #X186 @PLACE(216, 72) => @ORIENT("R0");
//   #X187 @PLACE(216, 64) => @ORIENT("R0");
//   #X188 @PLACE(216, 56) => @ORIENT("R0");
//   #X189 @PLACE(216, 48) => @ORIENT("R0");
//   #X190 @PLACE(216, 40) => @ORIENT("R0");
//   #X191 @PLACE(216, 32) => @ORIENT("R0");
//   #X192 @PLACE(216, 24) => @ORIENT("R0");
//   #X193 @PLACE(216, 16) => @ORIENT("R0");
//   #X194 @PLACE(216, 8) => @ORIENT("R0");
//   #X195 @PLACE(232, 144) => @ORIENT("R0");
//   #X196 @PLACE(232, 136) => @ORIENT("R0");
//   #X197 @PLACE(232, 128) => @ORIENT("R0");
//   #X198 @PLACE(232, 120) => @ORIENT("R0");
//   #X199 @PLACE(232, 112) => @ORIENT("R0");
//   #X200 @PLACE(232, 104) => @ORIENT("R0");
//   #X201 @PLACE(232, 96) => @ORIENT("R0");
//   #X202 @PLACE(232, 88) => @ORIENT("R0");
//   #X203 @PLACE(232, 80) => @ORIENT("R0");
//   #X204 @PLACE(232, 72) => @ORIENT("R0");
//   #X205 @PLACE(232, 64) => @ORIENT("R0");
//   #X206 @PLACE(232, 56) => @ORIENT("R0");
//   #X207 @PLACE(232, 48) => @ORIENT("R0");
//   #X208 @PLACE(232, 40) => @ORIENT("R0");
//   #X209 @PLACE(232, 32) => @ORIENT("R0");
//   #X210 @PLACE(232, 24) => @ORIENT("R0");
//   #X211 @PLACE(232, 16) => @ORIENT("R0");
//   #X212 @PLACE(232, 8) => @ORIENT("R0");
//   #X213 @PLACE(248, 144) => @ORIENT("R0");
//   #X214 @PLACE(248, 136) => @ORIENT("R0");
//   #X215 @PLACE(248, 128) => @ORIENT("R0");
//   #X216 @PLACE(248, 120) => @ORIENT("R0");
//   #X217 @PLACE(248, 112) => @ORIENT("R0");
//   #X218 @PLACE(248, 104) => @ORIENT("R0");
//   #X219 @PLACE(248, 96) => @ORIENT("R0");
//   #X220 @PLACE(248, 88) => @ORIENT("R0");
//   #X221 @PLACE(248, 80) => @ORIENT("R0");
//   #X222 @PLACE(248, 72) => @ORIENT("R0");
//   #X223 @PLACE(248, 64) => @ORIENT("R0");
//   #X224 @PLACE(248, 56) => @ORIENT("R0");
//   #X225 @PLACE(248, 48) => @ORIENT("R0");
//   #X226 @PLACE(248, 40) => @ORIENT("R0");
//   #X227 @PLACE(248, 32) => @ORIENT("R0");
//   #X228 @PLACE(248, 24) => @ORIENT("R0");
//   #X229 @PLACE(248, 16) => @ORIENT("R0");
//   #X230 @PLACE(248, 8) => @ORIENT("R0");
//   #X231 @PLACE(264, 144) => @ORIENT("R0");
//   #X232 @PLACE(264, 136) => @ORIENT("R0");
//   #X233 @PLACE(264, 128) => @ORIENT("R0");
//   #X234 @PLACE(264, 120) => @ORIENT("R0");
//   #X235 @PLACE(264, 112) => @ORIENT("R0");
//   #X236 @PLACE(264, 104) => @ORIENT("R0");
//   #X250 @PLACE(264, 96) => @ORIENT("R0");
//   #X251 @PLACE(264, 88) => @ORIENT("R0");
//   #X252 @PLACE(264, 80) => @ORIENT("R0");
//   #X253 @PLACE(264, 72) => @ORIENT("R0");
//   #X254 @PLACE(264, 64) => @ORIENT("R0");
//   #X255 @PLACE(264, 56) => @ORIENT("R0");
//   #X256 @PLACE(264, 48) => @ORIENT("R0");
//   #X257 @PLACE(264, 40) => @ORIENT("R0");
//   #X258 @PLACE(264, 32) => @ORIENT("R0");
//   #X259 @PLACE(264, 24) => @ORIENT("R0");
//   #X260 @PLACE(264, 16) => @ORIENT("R0");
//   #X261 @PLACE(264, 8) => @ORIENT("R0");
//   $GROUND @ATTACH #X237:a::net => %rnl_upgrade_usage_12 ; {%rnl_upgrade_usage_12::position #X237:a} @ALIGN("x"); {%rnl_upgrade_usage_12::position #X237:a} @ALIGN("y");
//   $GROUND @ATTACH #X238:a::net => %rnl_upgrade_usage_13 ; {%rnl_upgrade_usage_13::position #X238:a} @ALIGN("x"); {%rnl_upgrade_usage_13::position #X238:a} @ALIGN("y");
//   $GROUND @ATTACH #X239:a::net => %rnl_upgrade_usage_14 ; {%rnl_upgrade_usage_14::position #X239:a} @ALIGN("x"); {%rnl_upgrade_usage_14::position #X239:a} @ALIGN("y");
//   $GROUND @ATTACH #X240:a::net => %rnl_upgrade_usage_15 ; {%rnl_upgrade_usage_15::position #X240:a} @ALIGN("x"); {%rnl_upgrade_usage_15::position #X240:a} @ALIGN("y");
//   $GROUND @ATTACH #X241:a::net => %rnl_upgrade_usage_16 ; {%rnl_upgrade_usage_16::position #X241:a} @ALIGN("x"); {%rnl_upgrade_usage_16::position #X241:a} @ALIGN("y");
//   $GROUND @ATTACH #X242:a::net => %rnl_upgrade_usage_17 ; {%rnl_upgrade_usage_17::position #X242:a} @ALIGN("x"); {%rnl_upgrade_usage_17::position #X242:a} @ALIGN("y");
//   $GROUND @ATTACH #X243:a::net => %rnl_upgrade_usage_18 ; {%rnl_upgrade_usage_18::position #X243:a} @ALIGN("x"); {%rnl_upgrade_usage_18::position #X243:a} @ALIGN("y");
//   $GROUND @ATTACH #X244:a::net => %rnl_upgrade_usage_19 ; {%rnl_upgrade_usage_19::position #X244:a} @ALIGN("x"); {%rnl_upgrade_usage_19::position #X244:a} @ALIGN("y");
//   $GROUND @ATTACH #X245:a::net => %rnl_upgrade_usage_20 ; {%rnl_upgrade_usage_20::position #X245:a} @ALIGN("x"); {%rnl_upgrade_usage_20::position #X245:a} @ALIGN("y");
//   $GROUND @ATTACH #X247:a::net => %rnl_upgrade_usage_21 ; {%rnl_upgrade_usage_21::position #X247:a} @ALIGN("x"); {%rnl_upgrade_usage_21::position #X247:a} @ALIGN("y");
//   $SUPPLY @ATTACH #X248:a::net => %rnl_upgrade_usage_22 ; {%rnl_upgrade_usage_22::position #X248:a} @ALIGN("x"); {%rnl_upgrade_usage_22::position #X248:a} @ALIGN("y");
//   $GROUND @ATTACH #X249:a::net => %rnl_upgrade_usage_23 ; {%rnl_upgrade_usage_23::position #X249:a} @ALIGN("x"); {%rnl_upgrade_usage_23::position #X249:a} @ALIGN("y");
//
//   /* --- 3. Single-Line Port Buses & Flying-Wire Terminal Labels --- */
//   &refclk @WIRE { %p_refclk::pin (12, 127) } => @TEXT("refclk") => @SET-STYLE $fly_label_style;
//   &reset @WIRE { %p_reset::pin (12, 102) } => @TEXT("reset") => @SET-STYLE $fly_label_style;
//   &active @WIRE { %p_active::pin (12, 77) } => @TEXT("active") => @SET-STYLE $fly_label_style;
//   {&target_k0 &target_k1 &target_k2 &target_k3 &target_k4 &target_k5} @WIRE { %p_target_k0::pin (14, 52) } => @TEXT("TARGET_K<5:0>") => @SET-STYLE $bus_label_style;
//   {&measured0 &measured1 &measured2 &measured3 &measured4 &measured5 &measured6 &measured7 &measured8 &measured9 &measured10 &measured11 &measured12 &measured13} @WIRE { %p_measured0::pin (14, 27) } => @TEXT("MEASURED<13:0>") => @SET-STYLE $bus_label_style;
//   &count_gate @WIRE { (274, 122) %p_count_gate::pin } => @TEXT("count_gate") => @SET-STYLE $fly_label_style;
//   &count_reset @WIRE { (274, 92) %p_count_reset::pin } => @TEXT("count_reset") => @SET-STYLE $fly_label_style;
//   &frequency_good @WIRE { (274, 62) %p_frequency_good::pin } => @TEXT("frequency_good") => @SET-STYLE $fly_label_style;
//   &valid @WIRE { (274, 32) %p_valid::pin } => @TEXT("valid") => @SET-STYLE $fly_label_style;
//   #X0:d @TEXT("n29", dx=-0.4, dy=-0.25, halign="end") => @SET-STYLE $fly_label_style;
//   #X0:clk @TEXT("refclk", dx=-0.4, dy=-0.25, halign="end") => @SET-STYLE $fly_label_style;
//   #X0:reset @TEXT("reset", dx=0, dy=-1.0, halign="middle") => @SET-STYLE $fly_label_style;
//   #X0:q @TEXT("count_reset", dx=0.4, dy=-0.25, halign="start") => @SET-STYLE $fly_label_style;
//   #X1:d @TEXT("n30", dx=-0.4, dy=-0.25, halign="end") => @SET-STYLE $fly_label_style;
//   #X1:clk @TEXT("refclk", dx=-0.4, dy=-0.25, halign="end") => @SET-STYLE $fly_label_style;
//   #X1:reset @TEXT("reset", dx=0, dy=-1.0, halign="middle") => @SET-STYLE $fly_label_style;
//   #X1:q @TEXT("count_gate", dx=0.4, dy=-0.25, halign="start") => @SET-STYLE $fly_label_style;
//   #X2:d @TEXT("n31", dx=-0.4, dy=-0.25, halign="end") => @SET-STYLE $fly_label_style;
//   #X2:clk @TEXT("refclk", dx=-0.4, dy=-0.25, halign="end") => @SET-STYLE $fly_label_style;
//   #X2:reset @TEXT("reset", dx=0, dy=-1.0, halign="middle") => @SET-STYLE $fly_label_style;
//   #X2:q @TEXT("frequency_good", dx=0.4, dy=-0.25, halign="start") => @SET-STYLE $fly_label_style;
//   #X3:d @TEXT("n32", dx=-0.4, dy=-0.25, halign="end") => @SET-STYLE $fly_label_style;
//   #X3:clk @TEXT("refclk", dx=-0.4, dy=-0.25, halign="end") => @SET-STYLE $fly_label_style;
//   #X3:reset @TEXT("reset", dx=0, dy=-1.0, halign="middle") => @SET-STYLE $fly_label_style;
//   #X3:q @TEXT("valid", dx=0.4, dy=-0.25, halign="start") => @SET-STYLE $fly_label_style;
//   #X4:d @TEXT("n33", dx=-0.4, dy=-0.25, halign="end") => @SET-STYLE $fly_label_style;
//   #X4:clk @TEXT("refclk", dx=-0.4, dy=-0.25, halign="end") => @SET-STYLE $fly_label_style;
//   #X4:reset @TEXT("reset", dx=0, dy=-1.0, halign="middle") => @SET-STYLE $fly_label_style;
//   #X4:q @TEXT("n34", dx=0.4, dy=-0.25, halign="start") => @SET-STYLE $fly_label_style;
//   #X5:d @TEXT("n35", dx=-0.4, dy=-0.25, halign="end") => @SET-STYLE $fly_label_style;
//   #X5:clk @TEXT("refclk", dx=-0.4, dy=-0.25, halign="end") => @SET-STYLE $fly_label_style;
//   #X5:reset @TEXT("reset", dx=0, dy=-1.0, halign="middle") => @SET-STYLE $fly_label_style;
//   #X5:q @TEXT("n36", dx=0.4, dy=-0.25, halign="start") => @SET-STYLE $fly_label_style;
//   #X6:d @TEXT("n37", dx=-0.4, dy=-0.25, halign="end") => @SET-STYLE $fly_label_style;
//   #X6:clk @TEXT("refclk", dx=-0.4, dy=-0.25, halign="end") => @SET-STYLE $fly_label_style;
//   #X6:reset @TEXT("reset", dx=0, dy=-1.0, halign="middle") => @SET-STYLE $fly_label_style;
//   #X6:q @TEXT("n38", dx=0.4, dy=-0.25, halign="start") => @SET-STYLE $fly_label_style;
//   #X7:d @TEXT("n39", dx=-0.4, dy=-0.25, halign="end") => @SET-STYLE $fly_label_style;
//   #X7:clk @TEXT("refclk", dx=-0.4, dy=-0.25, halign="end") => @SET-STYLE $fly_label_style;
//   #X7:reset @TEXT("reset", dx=0, dy=-1.0, halign="middle") => @SET-STYLE $fly_label_style;
//   #X7:q @TEXT("n40", dx=0.4, dy=-0.25, halign="start") => @SET-STYLE $fly_label_style;
//   #X8:d @TEXT("n41", dx=-0.4, dy=-0.25, halign="end") => @SET-STYLE $fly_label_style;
//   #X8:clk @TEXT("refclk", dx=-0.4, dy=-0.25, halign="end") => @SET-STYLE $fly_label_style;
//   #X8:reset @TEXT("reset", dx=0, dy=-1.0, halign="middle") => @SET-STYLE $fly_label_style;
//   #X8:q @TEXT("n42", dx=0.4, dy=-0.25, halign="start") => @SET-STYLE $fly_label_style;
//   #X9:d @TEXT("n43", dx=-0.4, dy=-0.25, halign="end") => @SET-STYLE $fly_label_style;
//   #X9:clk @TEXT("refclk", dx=-0.4, dy=-0.25, halign="end") => @SET-STYLE $fly_label_style;
//   #X9:reset @TEXT("reset", dx=0, dy=-1.0, halign="middle") => @SET-STYLE $fly_label_style;
//   #X9:q @TEXT("n44", dx=0.4, dy=-0.25, halign="start") => @SET-STYLE $fly_label_style;
//   #X10:d @TEXT("n45", dx=-0.4, dy=-0.25, halign="end") => @SET-STYLE $fly_label_style;
//   #X10:clk @TEXT("refclk", dx=-0.4, dy=-0.25, halign="end") => @SET-STYLE $fly_label_style;
//   #X10:reset @TEXT("reset", dx=0, dy=-1.0, halign="middle") => @SET-STYLE $fly_label_style;
//   #X10:q @TEXT("n46", dx=0.4, dy=-0.25, halign="start") => @SET-STYLE $fly_label_style;
//   #X11:d @TEXT("n47", dx=-0.4, dy=-0.25, halign="end") => @SET-STYLE $fly_label_style;
//   #X11:clk @TEXT("refclk", dx=-0.4, dy=-0.25, halign="end") => @SET-STYLE $fly_label_style;
//   #X11:reset @TEXT("reset", dx=0, dy=-1.0, halign="middle") => @SET-STYLE $fly_label_style;
//   #X11:q @TEXT("n48", dx=0.4, dy=-0.25, halign="start") => @SET-STYLE $fly_label_style;
//   #X12:a @TEXT("count_reset", dx=-0.4, dy=-0.25, halign="end") => @SET-STYLE $fly_label_style;
//   #X12:b @TEXT("n49", dx=-0.4, dy=-0.25, halign="end") => @SET-STYLE $fly_label_style;
//   #X12:s @TEXT("n50", dx=0, dy=-1.0, halign="middle") => @SET-STYLE $fly_label_style;
//   #X12:y @TEXT("n29", dx=0.4, dy=-0.25, halign="start") => @SET-STYLE $fly_label_style;
//   #X13:a @TEXT("count_gate", dx=-0.4, dy=-0.25, halign="end") => @SET-STYLE $fly_label_style;
//   #X13:b @TEXT("n51", dx=-0.4, dy=-0.25, halign="end") => @SET-STYLE $fly_label_style;
//   #X13:s @TEXT("n52", dx=0, dy=-1.0, halign="middle") => @SET-STYLE $fly_label_style;
//   #X13:y @TEXT("n30", dx=0.4, dy=-0.25, halign="start") => @SET-STYLE $fly_label_style;
//   #X14:a @TEXT("frequency_good", dx=-0.4, dy=-0.25, halign="end") => @SET-STYLE $fly_label_style;
//   #X14:b @TEXT("n53", dx=-0.4, dy=-0.25, halign="end") => @SET-STYLE $fly_label_style;
//   #X14:s @TEXT("n54", dx=0, dy=-1.0, halign="middle") => @SET-STYLE $fly_label_style;
//   #X14:y @TEXT("n31", dx=0.4, dy=-0.25, halign="start") => @SET-STYLE $fly_label_style;
//   #X15:a @TEXT("measured1", dx=-0.4, dy=-0.25, halign="end") => @SET-STYLE $fly_label_style;
//   #X15:y @TEXT("n55", dx=0.4, dy=-0.25, halign="start") => @SET-STYLE $fly_label_style;
//   #X16:a @TEXT("measured4", dx=-0.4, dy=-0.25, halign="end") => @SET-STYLE $fly_label_style;
//   #X16:y @TEXT("n56", dx=0.4, dy=-0.25, halign="start") => @SET-STYLE $fly_label_style;
//   #X17:a @TEXT("measured3", dx=-0.4, dy=-0.25, halign="end") => @SET-STYLE $fly_label_style;
//   #X17:y @TEXT("n57", dx=0.4, dy=-0.25, halign="start") => @SET-STYLE $fly_label_style;
//   #X18:a @TEXT("measured2", dx=-0.4, dy=-0.25, halign="end") => @SET-STYLE $fly_label_style;
//   #X18:y @TEXT("n58", dx=0.4, dy=-0.25, halign="start") => @SET-STYLE $fly_label_style;
//   #X19:a @TEXT("measured11", dx=-0.4, dy=-0.25, halign="end") => @SET-STYLE $fly_label_style;
//   #X19:y @TEXT("n59", dx=0.4, dy=-0.25, halign="start") => @SET-STYLE $fly_label_style;
//   #X20:a @TEXT("measured13", dx=-0.4, dy=-0.25, halign="end") => @SET-STYLE $fly_label_style;
//   #X20:y @TEXT("n60", dx=0.4, dy=-0.25, halign="start") => @SET-STYLE $fly_label_style;
//   #X21:a @TEXT("measured12", dx=-0.4, dy=-0.25, halign="end") => @SET-STYLE $fly_label_style;
//   #X21:y @TEXT("n61", dx=0.4, dy=-0.25, halign="start") => @SET-STYLE $fly_label_style;
//   #X22:a @TEXT("n62", dx=-0.4, dy=-0.25, halign="end") => @SET-STYLE $fly_label_style;
//   #X22:y @TEXT("n63", dx=0.4, dy=-0.25, halign="start") => @SET-STYLE $fly_label_style;
//   #X23:a @TEXT("n64", dx=-0.4, dy=-0.25, halign="end") => @SET-STYLE $fly_label_style;
//   #X23:y @TEXT("n65", dx=0.4, dy=-0.25, halign="start") => @SET-STYLE $fly_label_style;
//   #X24:a @TEXT("n66", dx=-0.4, dy=-0.25, halign="end") => @SET-STYLE $fly_label_style;
//   #X24:y @TEXT("n67", dx=0.4, dy=-0.25, halign="start") => @SET-STYLE $fly_label_style;
//   #X25:a @TEXT("n68", dx=-0.4, dy=-0.25, halign="end") => @SET-STYLE $fly_label_style;
//   #X25:y @TEXT("n69", dx=0.4, dy=-0.25, halign="start") => @SET-STYLE $fly_label_style;
//   #X26:a @TEXT("n70", dx=-0.4, dy=-0.25, halign="end") => @SET-STYLE $fly_label_style;
//   #X26:y @TEXT("n71", dx=0.4, dy=-0.25, halign="start") => @SET-STYLE $fly_label_style;
//   #X27:a @TEXT("n72", dx=-0.4, dy=-0.25, halign="end") => @SET-STYLE $fly_label_style;
//   #X27:y @TEXT("n73", dx=0.4, dy=-0.25, halign="start") => @SET-STYLE $fly_label_style;
//   #X28:a @TEXT("n74", dx=-0.4, dy=-0.25, halign="end") => @SET-STYLE $fly_label_style;
//   #X28:y @TEXT("n75", dx=0.4, dy=-0.25, halign="start") => @SET-STYLE $fly_label_style;
//   #X29:a @TEXT("target_k1", dx=-0.4, dy=-0.25, halign="end") => @SET-STYLE $fly_label_style;
//   #X29:y @TEXT("n76", dx=0.4, dy=-0.25, halign="start") => @SET-STYLE $fly_label_style;
//   #X30:a @TEXT("target_k0", dx=-0.4, dy=-0.25, halign="end") => @SET-STYLE $fly_label_style;
//   #X30:y @TEXT("n77", dx=0.4, dy=-0.25, halign="start") => @SET-STYLE $fly_label_style;
//   #X31:a @TEXT("active", dx=-0.4, dy=-0.25, halign="end") => @SET-STYLE $fly_label_style;
//   #X31:y @TEXT("n78", dx=0.4, dy=-0.25, halign="start") => @SET-STYLE $fly_label_style;
//   #X32:a @TEXT("n79", dx=-0.4, dy=-0.25, halign="end") => @SET-STYLE $fly_label_style;
//   #X32:y @TEXT("n80", dx=0.4, dy=-0.25, halign="start") => @SET-STYLE $fly_label_style;
//   #X33:a @TEXT("n81", dx=-0.4, dy=-0.25, halign="end") => @SET-STYLE $fly_label_style;
//   #X33:y @TEXT("n82", dx=0.4, dy=-0.25, halign="start") => @SET-STYLE $fly_label_style;
//   #X34:a @TEXT("n38", dx=-0.4, dy=-0.25, halign="end") => @SET-STYLE $fly_label_style;
//   #X34:b @TEXT("n83", dx=-0.4, dy=-0.25, halign="end") => @SET-STYLE $fly_label_style;
//   #X34:y @TEXT("n84", dx=0.4, dy=-0.25, halign="start") => @SET-STYLE $fly_label_style;
//   #X35:a @TEXT("n42", dx=-0.4, dy=-0.25, halign="end") => @SET-STYLE $fly_label_style;
//   #X35:b @TEXT("n85", dx=-0.4, dy=-0.25, halign="end") => @SET-STYLE $fly_label_style;
//   #X35:y @TEXT("n86", dx=0.4, dy=-0.25, halign="start") => @SET-STYLE $fly_label_style;
//   #X36:a @TEXT("n87", dx=-0.4, dy=-0.25, halign="end") => @SET-STYLE $fly_label_style;
//   #X36:b @TEXT("n85", dx=-0.4, dy=-0.25, halign="end") => @SET-STYLE $fly_label_style;
//   #X36:y @TEXT("n88", dx=0.4, dy=-0.25, halign="start") => @SET-STYLE $fly_label_style;
//   #X37:a @TEXT("n46", dx=-0.4, dy=-0.25, halign="end") => @SET-STYLE $fly_label_style;
//   #X37:b @TEXT("n88", dx=-0.4, dy=-0.25, halign="end") => @SET-STYLE $fly_label_style;
//   #X37:y @TEXT("n89", dx=0.4, dy=-0.25, halign="start") => @SET-STYLE $fly_label_style;
//   #X38:a @TEXT("n90", dx=-0.4, dy=-0.25, halign="end") => @SET-STYLE $fly_label_style;
//   #X38:b @TEXT("n83", dx=-0.4, dy=-0.25, halign="end") => @SET-STYLE $fly_label_style;
//   #X38:y @TEXT("n85", dx=0.4, dy=-0.25, halign="start") => @SET-STYLE $fly_label_style;
//   #X39:a @TEXT("n44", dx=-0.4, dy=-0.25, halign="end") => @SET-STYLE $fly_label_style;
//   #X39:b @TEXT("n42", dx=-0.4, dy=-0.25, halign="end") => @SET-STYLE $fly_label_style;
//   #X39:y @TEXT("n87", dx=0.4, dy=-0.25, halign="start") => @SET-STYLE $fly_label_style;
//   #X40:a @TEXT("n40", dx=-0.4, dy=-0.25, halign="end") => @SET-STYLE $fly_label_style;
//   #X40:b @TEXT("n38", dx=-0.4, dy=-0.25, halign="end") => @SET-STYLE $fly_label_style;
//   #X40:y @TEXT("n90", dx=0.4, dy=-0.25, halign="start") => @SET-STYLE $fly_label_style;
//   #X41:a @TEXT("n36", dx=-0.4, dy=-0.25, halign="end") => @SET-STYLE $fly_label_style;
//   #X41:b @TEXT("n34", dx=-0.4, dy=-0.25, halign="end") => @SET-STYLE $fly_label_style;
//   #X41:y @TEXT("n83", dx=0.4, dy=-0.25, halign="start") => @SET-STYLE $fly_label_style;
//   #X42:a @TEXT("n91", dx=-0.4, dy=-0.25, halign="end") => @SET-STYLE $fly_label_style;
//   #X42:b @TEXT("n92", dx=-0.4, dy=-0.25, halign="end") => @SET-STYLE $fly_label_style;
//   #X42:y @TEXT("n81", dx=0.4, dy=-0.25, halign="start") => @SET-STYLE $fly_label_style;
//   #X43:a @TEXT("n93", dx=-0.4, dy=-0.25, halign="end") => @SET-STYLE $fly_label_style;
//   #X43:b @TEXT("n94", dx=-0.4, dy=-0.25, halign="end") => @SET-STYLE $fly_label_style;
//   #X43:y @TEXT("n92", dx=0.4, dy=-0.25, halign="start") => @SET-STYLE $fly_label_style;
//   #X44:a @TEXT("n95", dx=-0.4, dy=-0.25, halign="end") => @SET-STYLE $fly_label_style;
//   #X44:b @TEXT("n96", dx=-0.4, dy=-0.25, halign="end") => @SET-STYLE $fly_label_style;
//   #X44:y @TEXT("n94", dx=0.4, dy=-0.25, halign="start") => @SET-STYLE $fly_label_style;
//   #X45:a @TEXT("n97", dx=-0.4, dy=-0.25, halign="end") => @SET-STYLE $fly_label_style;
//   #X45:b @TEXT("n98", dx=-0.4, dy=-0.25, halign="end") => @SET-STYLE $fly_label_style;
//   #X45:y @TEXT("n96", dx=0.4, dy=-0.25, halign="start") => @SET-STYLE $fly_label_style;
//   #X46:a @TEXT("n99", dx=-0.4, dy=-0.25, halign="end") => @SET-STYLE $fly_label_style;
//   #X46:b @TEXT("n100", dx=-0.4, dy=-0.25, halign="end") => @SET-STYLE $fly_label_style;
//   #X46:y @TEXT("n93", dx=0.4, dy=-0.25, halign="start") => @SET-STYLE $fly_label_style;
//   #X47:a @TEXT("target_k5", dx=-0.4, dy=-0.25, halign="end") => @SET-STYLE $fly_label_style;
//   #X47:b @TEXT("n101", dx=-0.4, dy=-0.25, halign="end") => @SET-STYLE $fly_label_style;
//   #X47:y @TEXT("n91", dx=0.4, dy=-0.25, halign="start") => @SET-STYLE $fly_label_style;
//   #X48:a @TEXT("n99", dx=-0.4, dy=-0.25, halign="end") => @SET-STYLE $fly_label_style;
//   #X48:b @TEXT("target_k4", dx=-0.4, dy=-0.25, halign="end") => @SET-STYLE $fly_label_style;
//   #X48:y @TEXT("n101", dx=0.4, dy=-0.25, halign="start") => @SET-STYLE $fly_label_style;
//   #X49:a @TEXT("n102", dx=-0.4, dy=-0.25, halign="end") => @SET-STYLE $fly_label_style;
//   #X49:b @TEXT("n94", dx=-0.4, dy=-0.25, halign="end") => @SET-STYLE $fly_label_style;
//   #X49:y @TEXT("n103", dx=0.4, dy=-0.25, halign="start") => @SET-STYLE $fly_label_style;
//   #X50:a @TEXT("n104", dx=-0.4, dy=-0.25, halign="end") => @SET-STYLE $fly_label_style;
//   #X50:b @TEXT("n103", dx=-0.4, dy=-0.25, halign="end") => @SET-STYLE $fly_label_style;
//   #X50:y @TEXT("n79", dx=0.4, dy=-0.25, halign="start") => @SET-STYLE $fly_label_style;
//   #X51:a @TEXT("target_k5", dx=-0.4, dy=-0.25, halign="end") => @SET-STYLE $fly_label_style;
//   #X51:b @TEXT("target_k4", dx=-0.4, dy=-0.25, halign="end") => @SET-STYLE $fly_label_style;
//   #X51:y @TEXT("n104", dx=0.4, dy=-0.25, halign="start") => @SET-STYLE $fly_label_style;
//   #X52:a @TEXT("target_k3", dx=-0.4, dy=-0.25, halign="end") => @SET-STYLE $fly_label_style;
//   #X52:b @TEXT("target_k2", dx=-0.4, dy=-0.25, halign="end") => @SET-STYLE $fly_label_style;
//   #X52:y @TEXT("n95", dx=0.4, dy=-0.25, halign="start") => @SET-STYLE $fly_label_style;
//   #X53:a @TEXT("target_k1", dx=-0.4, dy=-0.25, halign="end") => @SET-STYLE $fly_label_style;
//   #X53:b @TEXT("n105", dx=-0.4, dy=-0.25, halign="end") => @SET-STYLE $fly_label_style;
//   #X53:y @TEXT("n98", dx=0.4, dy=-0.25, halign="start") => @SET-STYLE $fly_label_style;
//   #X54:a @TEXT("n76", dx=-0.4, dy=-0.25, halign="end") => @SET-STYLE $fly_label_style;
//   #X54:b @TEXT("target_k0", dx=-0.4, dy=-0.25, halign="end") => @SET-STYLE $fly_label_style;
//   #X54:y @TEXT("n105", dx=0.4, dy=-0.25, halign="start") => @SET-STYLE $fly_label_style;
//   #X55:a @TEXT("measured4", dx=-0.4, dy=-0.25, halign="end") => @SET-STYLE $fly_label_style;
//   #X55:b @TEXT("n106", dx=-0.4, dy=-0.25, halign="end") => @SET-STYLE $fly_label_style;
//   #X55:y @TEXT("n107", dx=0.4, dy=-0.25, halign="start") => @SET-STYLE $fly_label_style;
//   #X56:a @TEXT("measured2", dx=-0.4, dy=-0.25, halign="end") => @SET-STYLE $fly_label_style;
//   #X56:b @TEXT("n108", dx=-0.4, dy=-0.25, halign="end") => @SET-STYLE $fly_label_style;
//   #X56:y @TEXT("n109", dx=0.4, dy=-0.25, halign="start") => @SET-STYLE $fly_label_style;
//   #X57:a @TEXT("measured10", dx=-0.4, dy=-0.25, halign="end") => @SET-STYLE $fly_label_style;
//   #X57:b @TEXT("n110", dx=-0.4, dy=-0.25, halign="end") => @SET-STYLE $fly_label_style;
//   #X57:y @TEXT("n111", dx=0.4, dy=-0.25, halign="start") => @SET-STYLE $fly_label_style;
//   #X58:a @TEXT("n112", dx=-0.4, dy=-0.25, halign="end") => @SET-STYLE $fly_label_style;
//   #X58:b @TEXT("n113", dx=-0.4, dy=-0.25, halign="end") => @SET-STYLE $fly_label_style;
//   #X58:y @TEXT("n110", dx=0.4, dy=-0.25, halign="start") => @SET-STYLE $fly_label_style;
//   #X59:a @TEXT("n114", dx=-0.4, dy=-0.25, halign="end") => @SET-STYLE $fly_label_style;
//   #X59:b @TEXT("n106", dx=-0.4, dy=-0.25, halign="end") => @SET-STYLE $fly_label_style;
//   #X59:y @TEXT("n115", dx=0.4, dy=-0.25, halign="start") => @SET-STYLE $fly_label_style;
//   #X60:a @TEXT("measured6", dx=-0.4, dy=-0.25, halign="end") => @SET-STYLE $fly_label_style;
//   #X60:b @TEXT("n115", dx=-0.4, dy=-0.25, halign="end") => @SET-STYLE $fly_label_style;
//   #X60:y @TEXT("n116", dx=0.4, dy=-0.25, halign="start") => @SET-STYLE $fly_label_style;
//   #X61:a @TEXT("n117", dx=-0.4, dy=-0.25, halign="end") => @SET-STYLE $fly_label_style;
//   #X61:b @TEXT("n113", dx=-0.4, dy=-0.25, halign="end") => @SET-STYLE $fly_label_style;
//   #X61:y @TEXT("n118", dx=0.4, dy=-0.25, halign="start") => @SET-STYLE $fly_label_style;
//   #X62:a @TEXT("measured12", dx=-0.4, dy=-0.25, halign="end") => @SET-STYLE $fly_label_style;
//   #X62:b @TEXT("n118", dx=-0.4, dy=-0.25, halign="end") => @SET-STYLE $fly_label_style;
//   #X62:y @TEXT("n119", dx=0.4, dy=-0.25, halign="start") => @SET-STYLE $fly_label_style;
//   #X63:a @TEXT("n120", dx=-0.4, dy=-0.25, halign="end") => @SET-STYLE $fly_label_style;
//   #X63:b @TEXT("n106", dx=-0.4, dy=-0.25, halign="end") => @SET-STYLE $fly_label_style;
//   #X63:y @TEXT("n113", dx=0.4, dy=-0.25, halign="start") => @SET-STYLE $fly_label_style;
//   #X64:a @TEXT("n121", dx=-0.4, dy=-0.25, halign="end") => @SET-STYLE $fly_label_style;
//   #X64:b @TEXT("n112", dx=-0.4, dy=-0.25, halign="end") => @SET-STYLE $fly_label_style;
//   #X64:y @TEXT("n117", dx=0.4, dy=-0.25, halign="start") => @SET-STYLE $fly_label_style;
//   #X65:a @TEXT("n122", dx=-0.4, dy=-0.25, halign="end") => @SET-STYLE $fly_label_style;
//   #X65:b @TEXT("n114", dx=-0.4, dy=-0.25, halign="end") => @SET-STYLE $fly_label_style;
//   #X65:y @TEXT("n120", dx=0.4, dy=-0.25, halign="start") => @SET-STYLE $fly_label_style;
//   #X66:a @TEXT("n123", dx=-0.4, dy=-0.25, halign="end") => @SET-STYLE $fly_label_style;
//   #X66:b @TEXT("n108", dx=-0.4, dy=-0.25, halign="end") => @SET-STYLE $fly_label_style;
//   #X66:y @TEXT("n106", dx=0.4, dy=-0.25, halign="start") => @SET-STYLE $fly_label_style;
//   #X67:a @TEXT("measured11", dx=-0.4, dy=-0.25, halign="end") => @SET-STYLE $fly_label_style;
//   #X67:b @TEXT("measured10", dx=-0.4, dy=-0.25, halign="end") => @SET-STYLE $fly_label_style;
//   #X67:y @TEXT("n121", dx=0.4, dy=-0.25, halign="start") => @SET-STYLE $fly_label_style;
//   #X68:a @TEXT("measured9", dx=-0.4, dy=-0.25, halign="end") => @SET-STYLE $fly_label_style;
//   #X68:b @TEXT("measured8", dx=-0.4, dy=-0.25, halign="end") => @SET-STYLE $fly_label_style;
//   #X68:y @TEXT("n112", dx=0.4, dy=-0.25, halign="start") => @SET-STYLE $fly_label_style;
//   #X69:a @TEXT("measured7", dx=-0.4, dy=-0.25, halign="end") => @SET-STYLE $fly_label_style;
//   #X69:b @TEXT("measured6", dx=-0.4, dy=-0.25, halign="end") => @SET-STYLE $fly_label_style;
//   #X69:y @TEXT("n122", dx=0.4, dy=-0.25, halign="start") => @SET-STYLE $fly_label_style;
//   #X70:a @TEXT("measured5", dx=-0.4, dy=-0.25, halign="end") => @SET-STYLE $fly_label_style;
//   #X70:b @TEXT("measured4", dx=-0.4, dy=-0.25, halign="end") => @SET-STYLE $fly_label_style;
//   #X70:y @TEXT("n114", dx=0.4, dy=-0.25, halign="start") => @SET-STYLE $fly_label_style;
//   #X71:a @TEXT("measured3", dx=-0.4, dy=-0.25, halign="end") => @SET-STYLE $fly_label_style;
//   #X71:b @TEXT("measured2", dx=-0.4, dy=-0.25, halign="end") => @SET-STYLE $fly_label_style;
//   #X71:y @TEXT("n123", dx=0.4, dy=-0.25, halign="start") => @SET-STYLE $fly_label_style;
//   #X72:a @TEXT("measured8", dx=-0.4, dy=-0.25, halign="end") => @SET-STYLE $fly_label_style;
//   #X72:b @TEXT("n113", dx=-0.4, dy=-0.25, halign="end") => @SET-STYLE $fly_label_style;
//   #X72:y @TEXT("n124", dx=0.4, dy=-0.25, halign="start") => @SET-STYLE $fly_label_style;
//   #X73:a @TEXT("measured1", dx=-0.4, dy=-0.25, halign="end") => @SET-STYLE $fly_label_style;
//   #X73:b @TEXT("measured0", dx=-0.4, dy=-0.25, halign="end") => @SET-STYLE $fly_label_style;
//   #X73:y @TEXT("n108", dx=0.4, dy=-0.25, halign="start") => @SET-STYLE $fly_label_style;
//   #X74:a @TEXT("n125", dx=-0.4, dy=-0.25, halign="end") => @SET-STYLE $fly_label_style;
//   #X74:b @TEXT("n77", dx=-0.4, dy=-0.25, halign="end") => @SET-STYLE $fly_label_style;
//   #X74:y @TEXT("n126", dx=0.4, dy=-0.25, halign="start") => @SET-STYLE $fly_label_style;
//   #X75:a @TEXT("n127", dx=-0.4, dy=-0.25, halign="end") => @SET-STYLE $fly_label_style;
//   #X75:b @TEXT("n76", dx=-0.4, dy=-0.25, halign="end") => @SET-STYLE $fly_label_style;
//   #X75:y @TEXT("n128", dx=0.4, dy=-0.25, halign="start") => @SET-STYLE $fly_label_style;
//   #X76:a @TEXT("n129", dx=-0.4, dy=-0.25, halign="end") => @SET-STYLE $fly_label_style;
//   #X76:b @TEXT("n130", dx=-0.4, dy=-0.25, halign="end") => @SET-STYLE $fly_label_style;
//   #X76:y @TEXT("n131", dx=0.4, dy=-0.25, halign="start") => @SET-STYLE $fly_label_style;
//   #X77:a @TEXT("n132", dx=-0.4, dy=-0.25, halign="end") => @SET-STYLE $fly_label_style;
//   #X77:b @TEXT("n133", dx=-0.4, dy=-0.25, halign="end") => @SET-STYLE $fly_label_style;
//   #X77:y @TEXT("n134", dx=0.4, dy=-0.25, halign="start") => @SET-STYLE $fly_label_style;
//   #X78:a @TEXT("n135", dx=-0.4, dy=-0.25, halign="end") => @SET-STYLE $fly_label_style;
//   #X78:b @TEXT("n100", dx=-0.4, dy=-0.25, halign="end") => @SET-STYLE $fly_label_style;
//   #X78:y @TEXT("n136", dx=0.4, dy=-0.25, halign="start") => @SET-STYLE $fly_label_style;
//   #X79:a @TEXT("n137", dx=-0.4, dy=-0.25, halign="end") => @SET-STYLE $fly_label_style;
//   #X79:b @TEXT("n99", dx=-0.4, dy=-0.25, halign="end") => @SET-STYLE $fly_label_style;
//   #X79:y @TEXT("n138", dx=0.4, dy=-0.25, halign="start") => @SET-STYLE $fly_label_style;
//   #X80:a @TEXT("n125", dx=-0.4, dy=-0.25, halign="end") => @SET-STYLE $fly_label_style;
//   #X80:b @TEXT("n77", dx=-0.4, dy=-0.25, halign="end") => @SET-STYLE $fly_label_style;
//   #X80:y @TEXT("n139", dx=0.4, dy=-0.25, halign="start") => @SET-STYLE $fly_label_style;
//   #X81:a @TEXT("n127", dx=-0.4, dy=-0.25, halign="end") => @SET-STYLE $fly_label_style;
//   #X81:b @TEXT("n76", dx=-0.4, dy=-0.25, halign="end") => @SET-STYLE $fly_label_style;
//   #X81:y @TEXT("n140", dx=0.4, dy=-0.25, halign="start") => @SET-STYLE $fly_label_style;
//   #X82:a @TEXT("n129", dx=-0.4, dy=-0.25, halign="end") => @SET-STYLE $fly_label_style;
//   #X82:b @TEXT("n130", dx=-0.4, dy=-0.25, halign="end") => @SET-STYLE $fly_label_style;
//   #X82:y @TEXT("n141", dx=0.4, dy=-0.25, halign="start") => @SET-STYLE $fly_label_style;
//   #X83:a @TEXT("n132", dx=-0.4, dy=-0.25, halign="end") => @SET-STYLE $fly_label_style;
//   #X83:b @TEXT("n133", dx=-0.4, dy=-0.25, halign="end") => @SET-STYLE $fly_label_style;
//   #X83:y @TEXT("n142", dx=0.4, dy=-0.25, halign="start") => @SET-STYLE $fly_label_style;
//   #X84:a @TEXT("n135", dx=-0.4, dy=-0.25, halign="end") => @SET-STYLE $fly_label_style;
//   #X84:b @TEXT("n100", dx=-0.4, dy=-0.25, halign="end") => @SET-STYLE $fly_label_style;
//   #X84:y @TEXT("n143", dx=0.4, dy=-0.25, halign="start") => @SET-STYLE $fly_label_style;
//   #X85:a @TEXT("n137", dx=-0.4, dy=-0.25, halign="end") => @SET-STYLE $fly_label_style;
//   #X85:b @TEXT("n99", dx=-0.4, dy=-0.25, halign="end") => @SET-STYLE $fly_label_style;
//   #X85:y @TEXT("n144", dx=0.4, dy=-0.25, halign="start") => @SET-STYLE $fly_label_style;
//   #X86:a @TEXT("n145", dx=-0.4, dy=-0.25, halign="end") => @SET-STYLE $fly_label_style;
//   #X86:b @TEXT("n146", dx=-0.4, dy=-0.25, halign="end") => @SET-STYLE $fly_label_style;
//   #X86:y @TEXT("n147", dx=0.4, dy=-0.25, halign="start") => @SET-STYLE $fly_label_style;
//   #X87:a @TEXT("n148", dx=-0.4, dy=-0.25, halign="end") => @SET-STYLE $fly_label_style;
//   #X87:b @TEXT("n149", dx=-0.4, dy=-0.25, halign="end") => @SET-STYLE $fly_label_style;
//   #X87:y @TEXT("n146", dx=0.4, dy=-0.25, halign="start") => @SET-STYLE $fly_label_style;
//   #X88:a @TEXT("n150", dx=-0.4, dy=-0.25, halign="end") => @SET-STYLE $fly_label_style;
//   #X88:b @TEXT("n151", dx=-0.4, dy=-0.25, halign="end") => @SET-STYLE $fly_label_style;
//   #X88:y @TEXT("n149", dx=0.4, dy=-0.25, halign="start") => @SET-STYLE $fly_label_style;
//   #X89:a @TEXT("n152", dx=-0.4, dy=-0.25, halign="end") => @SET-STYLE $fly_label_style;
//   #X89:b @TEXT("n153", dx=-0.4, dy=-0.25, halign="end") => @SET-STYLE $fly_label_style;
//   #X89:y @TEXT("n151", dx=0.4, dy=-0.25, halign="start") => @SET-STYLE $fly_label_style;
//   #X90:a @TEXT("n154", dx=-0.4, dy=-0.25, halign="end") => @SET-STYLE $fly_label_style;
//   #X90:b @TEXT("n155", dx=-0.4, dy=-0.25, halign="end") => @SET-STYLE $fly_label_style;
//   #X90:y @TEXT("n153", dx=0.4, dy=-0.25, halign="start") => @SET-STYLE $fly_label_style;
//   #X91:a @TEXT("n156", dx=-0.4, dy=-0.25, halign="end") => @SET-STYLE $fly_label_style;
//   #X91:b @TEXT("n157", dx=-0.4, dy=-0.25, halign="end") => @SET-STYLE $fly_label_style;
//   #X91:y @TEXT("n155", dx=0.4, dy=-0.25, halign="start") => @SET-STYLE $fly_label_style;
//   #X92:a @TEXT("n158", dx=-0.4, dy=-0.25, halign="end") => @SET-STYLE $fly_label_style;
//   #X92:b @TEXT("n159", dx=-0.4, dy=-0.25, halign="end") => @SET-STYLE $fly_label_style;
//   #X92:y @TEXT("n150", dx=0.4, dy=-0.25, halign="start") => @SET-STYLE $fly_label_style;
//   #X93:a @TEXT("n160", dx=-0.4, dy=-0.25, halign="end") => @SET-STYLE $fly_label_style;
//   #X93:b @TEXT("n161", dx=-0.4, dy=-0.25, halign="end") => @SET-STYLE $fly_label_style;
//   #X93:y @TEXT("n159", dx=0.4, dy=-0.25, halign="start") => @SET-STYLE $fly_label_style;
//   #X94:a @TEXT("n162", dx=-0.4, dy=-0.25, halign="end") => @SET-STYLE $fly_label_style;
//   #X94:b @TEXT("n163", dx=-0.4, dy=-0.25, halign="end") => @SET-STYLE $fly_label_style;
//   #X94:y @TEXT("n154", dx=0.4, dy=-0.25, halign="start") => @SET-STYLE $fly_label_style;
//   #X95:a @TEXT("n164", dx=-0.4, dy=-0.25, halign="end") => @SET-STYLE $fly_label_style;
//   #X95:b @TEXT("n165", dx=-0.4, dy=-0.25, halign="end") => @SET-STYLE $fly_label_style;
//   #X95:y @TEXT("n163", dx=0.4, dy=-0.25, halign="start") => @SET-STYLE $fly_label_style;
//   #X96:a @TEXT("n166", dx=-0.4, dy=-0.25, halign="end") => @SET-STYLE $fly_label_style;
//   #X96:b @TEXT("n167", dx=-0.4, dy=-0.25, halign="end") => @SET-STYLE $fly_label_style;
//   #X96:y @TEXT("n157", dx=0.4, dy=-0.25, halign="start") => @SET-STYLE $fly_label_style;
//   #X97:a @TEXT("n72", dx=-0.4, dy=-0.25, halign="end") => @SET-STYLE $fly_label_style;
//   #X97:b @TEXT("n168", dx=-0.4, dy=-0.25, halign="end") => @SET-STYLE $fly_label_style;
//   #X97:y @TEXT("n145", dx=0.4, dy=-0.25, halign="start") => @SET-STYLE $fly_label_style;
//   #X98:a @TEXT("n73", dx=-0.4, dy=-0.25, halign="end") => @SET-STYLE $fly_label_style;
//   #X98:b @TEXT("n74", dx=-0.4, dy=-0.25, halign="end") => @SET-STYLE $fly_label_style;
//   #X98:y @TEXT("n168", dx=0.4, dy=-0.25, halign="start") => @SET-STYLE $fly_label_style;
//   #X99:a @TEXT("n71", dx=-0.4, dy=-0.25, halign="end") => @SET-STYLE $fly_label_style;
//   #X99:b @TEXT("n144", dx=-0.4, dy=-0.25, halign="end") => @SET-STYLE $fly_label_style;
//   #X99:y @TEXT("n160", dx=0.4, dy=-0.25, halign="start") => @SET-STYLE $fly_label_style;
//   #X100:a @TEXT("n70", dx=-0.4, dy=-0.25, halign="end") => @SET-STYLE $fly_label_style;
//   #X100:b @TEXT("n169", dx=-0.4, dy=-0.25, halign="end") => @SET-STYLE $fly_label_style;
//   #X100:y @TEXT("n158", dx=0.4, dy=-0.25, halign="start") => @SET-STYLE $fly_label_style;
//   #X101:a @TEXT("n71", dx=-0.4, dy=-0.25, halign="end") => @SET-STYLE $fly_label_style;
//   #X101:b @TEXT("n138", dx=-0.4, dy=-0.25, halign="end") => @SET-STYLE $fly_label_style;
//   #X101:y @TEXT("n169", dx=0.4, dy=-0.25, halign="start") => @SET-STYLE $fly_label_style;
//   #X102:a @TEXT("n143", dx=-0.4, dy=-0.25, halign="end") => @SET-STYLE $fly_label_style;
//   #X102:b @TEXT("n142", dx=-0.4, dy=-0.25, halign="end") => @SET-STYLE $fly_label_style;
//   #X102:y @TEXT("n170", dx=0.4, dy=-0.25, halign="start") => @SET-STYLE $fly_label_style;
//   #X103:a @TEXT("n136", dx=-0.4, dy=-0.25, halign="end") => @SET-STYLE $fly_label_style;
//   #X103:b @TEXT("n171", dx=-0.4, dy=-0.25, halign="end") => @SET-STYLE $fly_label_style;
//   #X103:y @TEXT("n161", dx=0.4, dy=-0.25, halign="start") => @SET-STYLE $fly_label_style;
//   #X104:a @TEXT("n143", dx=-0.4, dy=-0.25, halign="end") => @SET-STYLE $fly_label_style;
//   #X104:b @TEXT("n134", dx=-0.4, dy=-0.25, halign="end") => @SET-STYLE $fly_label_style;
//   #X104:y @TEXT("n171", dx=0.4, dy=-0.25, halign="start") => @SET-STYLE $fly_label_style;
//   #X105:a @TEXT("n131", dx=-0.4, dy=-0.25, halign="end") => @SET-STYLE $fly_label_style;
//   #X105:b @TEXT("n172", dx=-0.4, dy=-0.25, halign="end") => @SET-STYLE $fly_label_style;
//   #X105:y @TEXT("n162", dx=0.4, dy=-0.25, halign="start") => @SET-STYLE $fly_label_style;
//   #X106:a @TEXT("n141", dx=-0.4, dy=-0.25, halign="end") => @SET-STYLE $fly_label_style;
//   #X106:b @TEXT("n128", dx=-0.4, dy=-0.25, halign="end") => @SET-STYLE $fly_label_style;
//   #X106:y @TEXT("n172", dx=0.4, dy=-0.25, halign="start") => @SET-STYLE $fly_label_style;
//   #X107:a @TEXT("n126", dx=-0.4, dy=-0.25, halign="end") => @SET-STYLE $fly_label_style;
//   #X107:b @TEXT("n173", dx=-0.4, dy=-0.25, halign="end") => @SET-STYLE $fly_label_style;
//   #X107:y @TEXT("n165", dx=0.4, dy=-0.25, halign="start") => @SET-STYLE $fly_label_style;
//   #X108:a @TEXT("n139", dx=-0.4, dy=-0.25, halign="end") => @SET-STYLE $fly_label_style;
//   #X108:b @TEXT("n64", dx=-0.4, dy=-0.25, halign="end") => @SET-STYLE $fly_label_style;
//   #X108:y @TEXT("n173", dx=0.4, dy=-0.25, halign="start") => @SET-STYLE $fly_label_style;
//   #X109:a @TEXT("n67", dx=-0.4, dy=-0.25, halign="end") => @SET-STYLE $fly_label_style;
//   #X109:b @TEXT("n69", dx=-0.4, dy=-0.25, halign="end") => @SET-STYLE $fly_label_style;
//   #X109:y @TEXT("n167", dx=0.4, dy=-0.25, halign="start") => @SET-STYLE $fly_label_style;
//   #X110:a @TEXT("n66", dx=-0.4, dy=-0.25, halign="end") => @SET-STYLE $fly_label_style;
//   #X110:b @TEXT("n174", dx=-0.4, dy=-0.25, halign="end") => @SET-STYLE $fly_label_style;
//   #X110:y @TEXT("n166", dx=0.4, dy=-0.25, halign="start") => @SET-STYLE $fly_label_style;
//   #X111:a @TEXT("n67", dx=-0.4, dy=-0.25, halign="end") => @SET-STYLE $fly_label_style;
//   #X111:b @TEXT("n68", dx=-0.4, dy=-0.25, halign="end") => @SET-STYLE $fly_label_style;
//   #X111:y @TEXT("n174", dx=0.4, dy=-0.25, halign="start") => @SET-STYLE $fly_label_style;
//   #X112:a @TEXT("measured5", dx=-0.4, dy=-0.25, halign="end") => @SET-STYLE $fly_label_style;
//   #X112:b @TEXT("n77", dx=-0.4, dy=-0.25, halign="end") => @SET-STYLE $fly_label_style;
//   #X112:y @TEXT("n175", dx=0.4, dy=-0.25, halign="start") => @SET-STYLE $fly_label_style;
//   #X113:a @TEXT("measured6", dx=-0.4, dy=-0.25, halign="end") => @SET-STYLE $fly_label_style;
//   #X113:b @TEXT("n76", dx=-0.4, dy=-0.25, halign="end") => @SET-STYLE $fly_label_style;
//   #X113:y @TEXT("n176", dx=0.4, dy=-0.25, halign="start") => @SET-STYLE $fly_label_style;
//   #X114:a @TEXT("measured7", dx=-0.4, dy=-0.25, halign="end") => @SET-STYLE $fly_label_style;
//   #X114:b @TEXT("n130", dx=-0.4, dy=-0.25, halign="end") => @SET-STYLE $fly_label_style;
//   #X114:y @TEXT("n177", dx=0.4, dy=-0.25, halign="start") => @SET-STYLE $fly_label_style;
//   #X115:a @TEXT("measured8", dx=-0.4, dy=-0.25, halign="end") => @SET-STYLE $fly_label_style;
//   #X115:b @TEXT("n133", dx=-0.4, dy=-0.25, halign="end") => @SET-STYLE $fly_label_style;
//   #X115:y @TEXT("n178", dx=0.4, dy=-0.25, halign="start") => @SET-STYLE $fly_label_style;
//   #X116:a @TEXT("measured9", dx=-0.4, dy=-0.25, halign="end") => @SET-STYLE $fly_label_style;
//   #X116:b @TEXT("n100", dx=-0.4, dy=-0.25, halign="end") => @SET-STYLE $fly_label_style;
//   #X116:y @TEXT("n179", dx=0.4, dy=-0.25, halign="start") => @SET-STYLE $fly_label_style;
//   #X117:a @TEXT("measured10", dx=-0.4, dy=-0.25, halign="end") => @SET-STYLE $fly_label_style;
//   #X117:b @TEXT("n99", dx=-0.4, dy=-0.25, halign="end") => @SET-STYLE $fly_label_style;
//   #X117:y @TEXT("n180", dx=0.4, dy=-0.25, halign="start") => @SET-STYLE $fly_label_style;
//   #X118:a @TEXT("measured5", dx=-0.4, dy=-0.25, halign="end") => @SET-STYLE $fly_label_style;
//   #X118:b @TEXT("n77", dx=-0.4, dy=-0.25, halign="end") => @SET-STYLE $fly_label_style;
//   #X118:y @TEXT("n181", dx=0.4, dy=-0.25, halign="start") => @SET-STYLE $fly_label_style;
//   #X119:a @TEXT("measured6", dx=-0.4, dy=-0.25, halign="end") => @SET-STYLE $fly_label_style;
//   #X119:b @TEXT("n76", dx=-0.4, dy=-0.25, halign="end") => @SET-STYLE $fly_label_style;
//   #X119:y @TEXT("n182", dx=0.4, dy=-0.25, halign="start") => @SET-STYLE $fly_label_style;
//   #X120:a @TEXT("measured7", dx=-0.4, dy=-0.25, halign="end") => @SET-STYLE $fly_label_style;
//   #X120:b @TEXT("n130", dx=-0.4, dy=-0.25, halign="end") => @SET-STYLE $fly_label_style;
//   #X120:y @TEXT("n183", dx=0.4, dy=-0.25, halign="start") => @SET-STYLE $fly_label_style;
//   #X121:a @TEXT("measured8", dx=-0.4, dy=-0.25, halign="end") => @SET-STYLE $fly_label_style;
//   #X121:b @TEXT("n133", dx=-0.4, dy=-0.25, halign="end") => @SET-STYLE $fly_label_style;
//   #X121:y @TEXT("n184", dx=0.4, dy=-0.25, halign="start") => @SET-STYLE $fly_label_style;
//   #X122:a @TEXT("measured9", dx=-0.4, dy=-0.25, halign="end") => @SET-STYLE $fly_label_style;
//   #X122:b @TEXT("n100", dx=-0.4, dy=-0.25, halign="end") => @SET-STYLE $fly_label_style;
//   #X122:y @TEXT("n185", dx=0.4, dy=-0.25, halign="start") => @SET-STYLE $fly_label_style;
//   #X123:a @TEXT("measured10", dx=-0.4, dy=-0.25, halign="end") => @SET-STYLE $fly_label_style;
//   #X123:b @TEXT("n99", dx=-0.4, dy=-0.25, halign="end") => @SET-STYLE $fly_label_style;
//   #X123:y @TEXT("n186", dx=0.4, dy=-0.25, halign="start") => @SET-STYLE $fly_label_style;
//   #X124:a @TEXT("n187", dx=-0.4, dy=-0.25, halign="end") => @SET-STYLE $fly_label_style;
//   #X124:b @TEXT("n188", dx=-0.4, dy=-0.25, halign="end") => @SET-STYLE $fly_label_style;
//   #X124:y @TEXT("n189", dx=0.4, dy=-0.25, halign="start") => @SET-STYLE $fly_label_style;
//   #X125:a @TEXT("n190", dx=-0.4, dy=-0.25, halign="end") => @SET-STYLE $fly_label_style;
//   #X125:b @TEXT("n191", dx=-0.4, dy=-0.25, halign="end") => @SET-STYLE $fly_label_style;
//   #X125:y @TEXT("n188", dx=0.4, dy=-0.25, halign="start") => @SET-STYLE $fly_label_style;
//   #X126:a @TEXT("n192", dx=-0.4, dy=-0.25, halign="end") => @SET-STYLE $fly_label_style;
//   #X126:b @TEXT("n193", dx=-0.4, dy=-0.25, halign="end") => @SET-STYLE $fly_label_style;
//   #X126:y @TEXT("n191", dx=0.4, dy=-0.25, halign="start") => @SET-STYLE $fly_label_style;
//   #X127:a @TEXT("n194", dx=-0.4, dy=-0.25, halign="end") => @SET-STYLE $fly_label_style;
//   #X127:b @TEXT("n195", dx=-0.4, dy=-0.25, halign="end") => @SET-STYLE $fly_label_style;
//   #X127:y @TEXT("n193", dx=0.4, dy=-0.25, halign="start") => @SET-STYLE $fly_label_style;
//   #X128:a @TEXT("n196", dx=-0.4, dy=-0.25, halign="end") => @SET-STYLE $fly_label_style;
//   #X128:b @TEXT("n197", dx=-0.4, dy=-0.25, halign="end") => @SET-STYLE $fly_label_style;
//   #X128:y @TEXT("n195", dx=0.4, dy=-0.25, halign="start") => @SET-STYLE $fly_label_style;
//   #X129:a @TEXT("n198", dx=-0.4, dy=-0.25, halign="end") => @SET-STYLE $fly_label_style;
//   #X129:b @TEXT("n199", dx=-0.4, dy=-0.25, halign="end") => @SET-STYLE $fly_label_style;
//   #X129:y @TEXT("n197", dx=0.4, dy=-0.25, halign="start") => @SET-STYLE $fly_label_style;
//   #X130:a @TEXT("n200", dx=-0.4, dy=-0.25, halign="end") => @SET-STYLE $fly_label_style;
//   #X130:b @TEXT("n201", dx=-0.4, dy=-0.25, halign="end") => @SET-STYLE $fly_label_style;
//   #X130:y @TEXT("n192", dx=0.4, dy=-0.25, halign="start") => @SET-STYLE $fly_label_style;
//   #X131:a @TEXT("n202", dx=-0.4, dy=-0.25, halign="end") => @SET-STYLE $fly_label_style;
//   #X131:b @TEXT("n203", dx=-0.4, dy=-0.25, halign="end") => @SET-STYLE $fly_label_style;
//   #X131:y @TEXT("n201", dx=0.4, dy=-0.25, halign="start") => @SET-STYLE $fly_label_style;
//   #X132:a @TEXT("n204", dx=-0.4, dy=-0.25, halign="end") => @SET-STYLE $fly_label_style;
//   #X132:b @TEXT("n205", dx=-0.4, dy=-0.25, halign="end") => @SET-STYLE $fly_label_style;
//   #X132:y @TEXT("n196", dx=0.4, dy=-0.25, halign="start") => @SET-STYLE $fly_label_style;
//   #X133:a @TEXT("n206", dx=-0.4, dy=-0.25, halign="end") => @SET-STYLE $fly_label_style;
//   #X133:b @TEXT("n207", dx=-0.4, dy=-0.25, halign="end") => @SET-STYLE $fly_label_style;
//   #X133:y @TEXT("n205", dx=0.4, dy=-0.25, halign="start") => @SET-STYLE $fly_label_style;
//   #X134:a @TEXT("n208", dx=-0.4, dy=-0.25, halign="end") => @SET-STYLE $fly_label_style;
//   #X134:b @TEXT("n209", dx=-0.4, dy=-0.25, halign="end") => @SET-STYLE $fly_label_style;
//   #X134:y @TEXT("n199", dx=0.4, dy=-0.25, halign="start") => @SET-STYLE $fly_label_style;
//   #X135:a @TEXT("n210", dx=-0.4, dy=-0.25, halign="end") => @SET-STYLE $fly_label_style;
//   #X135:b @TEXT("n211", dx=-0.4, dy=-0.25, halign="end") => @SET-STYLE $fly_label_style;
//   #X135:y @TEXT("n209", dx=0.4, dy=-0.25, halign="start") => @SET-STYLE $fly_label_style;
//   #X136:a @TEXT("measured13", dx=-0.4, dy=-0.25, halign="end") => @SET-STYLE $fly_label_style;
//   #X136:b @TEXT("n212", dx=-0.4, dy=-0.25, halign="end") => @SET-STYLE $fly_label_style;
//   #X136:y @TEXT("n187", dx=0.4, dy=-0.25, halign="start") => @SET-STYLE $fly_label_style;
//   #X137:a @TEXT("n60", dx=-0.4, dy=-0.25, halign="end") => @SET-STYLE $fly_label_style;
//   #X137:b @TEXT("measured12", dx=-0.4, dy=-0.25, halign="end") => @SET-STYLE $fly_label_style;
//   #X137:y @TEXT("n212", dx=0.4, dy=-0.25, halign="start") => @SET-STYLE $fly_label_style;
//   #X138:a @TEXT("measured11", dx=-0.4, dy=-0.25, halign="end") => @SET-STYLE $fly_label_style;
//   #X138:b @TEXT("n213", dx=-0.4, dy=-0.25, halign="end") => @SET-STYLE $fly_label_style;
//   #X138:y @TEXT("n200", dx=0.4, dy=-0.25, halign="start") => @SET-STYLE $fly_label_style;
//   #X139:a @TEXT("n59", dx=-0.4, dy=-0.25, halign="end") => @SET-STYLE $fly_label_style;
//   #X139:b @TEXT("n180", dx=-0.4, dy=-0.25, halign="end") => @SET-STYLE $fly_label_style;
//   #X139:y @TEXT("n213", dx=0.4, dy=-0.25, halign="start") => @SET-STYLE $fly_label_style;
//   #X140:a @TEXT("n185", dx=-0.4, dy=-0.25, halign="end") => @SET-STYLE $fly_label_style;
//   #X140:b @TEXT("n184", dx=-0.4, dy=-0.25, halign="end") => @SET-STYLE $fly_label_style;
//   #X140:y @TEXT("n214", dx=0.4, dy=-0.25, halign="start") => @SET-STYLE $fly_label_style;
//   #X141:a @TEXT("n179", dx=-0.4, dy=-0.25, halign="end") => @SET-STYLE $fly_label_style;
//   #X141:b @TEXT("n215", dx=-0.4, dy=-0.25, halign="end") => @SET-STYLE $fly_label_style;
//   #X141:y @TEXT("n203", dx=0.4, dy=-0.25, halign="start") => @SET-STYLE $fly_label_style;
//   #X142:a @TEXT("n185", dx=-0.4, dy=-0.25, halign="end") => @SET-STYLE $fly_label_style;
//   #X142:b @TEXT("n178", dx=-0.4, dy=-0.25, halign="end") => @SET-STYLE $fly_label_style;
//   #X142:y @TEXT("n215", dx=0.4, dy=-0.25, halign="start") => @SET-STYLE $fly_label_style;
//   #X143:a @TEXT("n183", dx=-0.4, dy=-0.25, halign="end") => @SET-STYLE $fly_label_style;
//   #X143:b @TEXT("n182", dx=-0.4, dy=-0.25, halign="end") => @SET-STYLE $fly_label_style;
//   #X143:y @TEXT("n206", dx=0.4, dy=-0.25, halign="start") => @SET-STYLE $fly_label_style;
//   #X144:a @TEXT("n177", dx=-0.4, dy=-0.25, halign="end") => @SET-STYLE $fly_label_style;
//   #X144:b @TEXT("n216", dx=-0.4, dy=-0.25, halign="end") => @SET-STYLE $fly_label_style;
//   #X144:y @TEXT("n204", dx=0.4, dy=-0.25, halign="start") => @SET-STYLE $fly_label_style;
//   #X145:a @TEXT("n183", dx=-0.4, dy=-0.25, halign="end") => @SET-STYLE $fly_label_style;
//   #X145:b @TEXT("n176", dx=-0.4, dy=-0.25, halign="end") => @SET-STYLE $fly_label_style;
//   #X145:y @TEXT("n216", dx=0.4, dy=-0.25, halign="start") => @SET-STYLE $fly_label_style;
//   #X146:a @TEXT("n181", dx=-0.4, dy=-0.25, halign="end") => @SET-STYLE $fly_label_style;
//   #X146:b @TEXT("n56", dx=-0.4, dy=-0.25, halign="end") => @SET-STYLE $fly_label_style;
//   #X146:y @TEXT("n217", dx=0.4, dy=-0.25, halign="start") => @SET-STYLE $fly_label_style;
//   #X147:a @TEXT("n175", dx=-0.4, dy=-0.25, halign="end") => @SET-STYLE $fly_label_style;
//   #X147:b @TEXT("n218", dx=-0.4, dy=-0.25, halign="end") => @SET-STYLE $fly_label_style;
//   #X147:y @TEXT("n207", dx=0.4, dy=-0.25, halign="start") => @SET-STYLE $fly_label_style;
//   #X148:a @TEXT("n181", dx=-0.4, dy=-0.25, halign="end") => @SET-STYLE $fly_label_style;
//   #X148:b @TEXT("measured4", dx=-0.4, dy=-0.25, halign="end") => @SET-STYLE $fly_label_style;
//   #X148:y @TEXT("n218", dx=0.4, dy=-0.25, halign="start") => @SET-STYLE $fly_label_style;
//   #X149:a @TEXT("measured3", dx=-0.4, dy=-0.25, halign="end") => @SET-STYLE $fly_label_style;
//   #X149:b @TEXT("n219", dx=-0.4, dy=-0.25, halign="end") => @SET-STYLE $fly_label_style;
//   #X149:y @TEXT("n208", dx=0.4, dy=-0.25, halign="start") => @SET-STYLE $fly_label_style;
//   #X150:a @TEXT("n57", dx=-0.4, dy=-0.25, halign="end") => @SET-STYLE $fly_label_style;
//   #X150:b @TEXT("measured2", dx=-0.4, dy=-0.25, halign="end") => @SET-STYLE $fly_label_style;
//   #X150:y @TEXT("n219", dx=0.4, dy=-0.25, halign="start") => @SET-STYLE $fly_label_style;
//   #X151:a @TEXT("measured1", dx=-0.4, dy=-0.25, halign="end") => @SET-STYLE $fly_label_style;
//   #X151:b @TEXT("n220", dx=-0.4, dy=-0.25, halign="end") => @SET-STYLE $fly_label_style;
//   #X151:y @TEXT("n211", dx=0.4, dy=-0.25, halign="start") => @SET-STYLE $fly_label_style;
//   #X152:a @TEXT("n55", dx=-0.4, dy=-0.25, halign="end") => @SET-STYLE $fly_label_style;
//   #X152:b @TEXT("measured0", dx=-0.4, dy=-0.25, halign="end") => @SET-STYLE $fly_label_style;
//   #X152:y @TEXT("n220", dx=0.4, dy=-0.25, halign="start") => @SET-STYLE $fly_label_style;
//   #X153:a @TEXT("n82", dx=-0.4, dy=-0.25, halign="end") => @SET-STYLE $fly_label_style;
//   #X153:b @TEXT("n221", dx=-0.4, dy=-0.25, halign="end") => @SET-STYLE $fly_label_style;
//   #X153:y @TEXT("n222", dx=0.4, dy=-0.25, halign="start") => @SET-STYLE $fly_label_style;
//   #X154:a @TEXT("n223", dx=-0.4, dy=-0.25, halign="end") => @SET-STYLE $fly_label_style;
//   #X154:b @TEXT("n224", dx=-0.4, dy=-0.25, halign="end") => @SET-STYLE $fly_label_style;
//   #X154:y @TEXT("n225", dx=0.4, dy=-0.25, halign="start") => @SET-STYLE $fly_label_style;
//   #X155:a @TEXT("n36", dx=-0.4, dy=-0.25, halign="end") => @SET-STYLE $fly_label_style;
//   #X155:b @TEXT("n34", dx=-0.4, dy=-0.25, halign="end") => @SET-STYLE $fly_label_style;
//   #X155:y @TEXT("n226", dx=0.4, dy=-0.25, halign="start") => @SET-STYLE $fly_label_style;
//   #X156:a @TEXT("n38", dx=-0.4, dy=-0.25, halign="end") => @SET-STYLE $fly_label_style;
//   #X156:b @TEXT("n83", dx=-0.4, dy=-0.25, halign="end") => @SET-STYLE $fly_label_style;
//   #X156:y @TEXT("n227", dx=0.4, dy=-0.25, halign="start") => @SET-STYLE $fly_label_style;
//   #X157:a @TEXT("n40", dx=-0.4, dy=-0.25, halign="end") => @SET-STYLE $fly_label_style;
//   #X157:b @TEXT("n84", dx=-0.4, dy=-0.25, halign="end") => @SET-STYLE $fly_label_style;
//   #X157:y @TEXT("n228", dx=0.4, dy=-0.25, halign="start") => @SET-STYLE $fly_label_style;
//   #X158:a @TEXT("n42", dx=-0.4, dy=-0.25, halign="end") => @SET-STYLE $fly_label_style;
//   #X158:b @TEXT("n85", dx=-0.4, dy=-0.25, halign="end") => @SET-STYLE $fly_label_style;
//   #X158:y @TEXT("n229", dx=0.4, dy=-0.25, halign="start") => @SET-STYLE $fly_label_style;
//   #X159:a @TEXT("n44", dx=-0.4, dy=-0.25, halign="end") => @SET-STYLE $fly_label_style;
//   #X159:b @TEXT("n86", dx=-0.4, dy=-0.25, halign="end") => @SET-STYLE $fly_label_style;
//   #X159:y @TEXT("n230", dx=0.4, dy=-0.25, halign="start") => @SET-STYLE $fly_label_style;
//   #X160:a @TEXT("n46", dx=-0.4, dy=-0.25, halign="end") => @SET-STYLE $fly_label_style;
//   #X160:b @TEXT("n88", dx=-0.4, dy=-0.25, halign="end") => @SET-STYLE $fly_label_style;
//   #X160:y @TEXT("n231", dx=0.4, dy=-0.25, halign="start") => @SET-STYLE $fly_label_style;
//   #X161:a @TEXT("n48", dx=-0.4, dy=-0.25, halign="end") => @SET-STYLE $fly_label_style;
//   #X161:b @TEXT("n89", dx=-0.4, dy=-0.25, halign="end") => @SET-STYLE $fly_label_style;
//   #X161:y @TEXT("n232", dx=0.4, dy=-0.25, halign="start") => @SET-STYLE $fly_label_style;
//   #X162:a @TEXT("measured1", dx=-0.4, dy=-0.25, halign="end") => @SET-STYLE $fly_label_style;
//   #X162:b @TEXT("measured0", dx=-0.4, dy=-0.25, halign="end") => @SET-STYLE $fly_label_style;
//   #X162:y @TEXT("n62", dx=0.4, dy=-0.25, halign="start") => @SET-STYLE $fly_label_style;
//   #X163:a @TEXT("measured2", dx=-0.4, dy=-0.25, halign="end") => @SET-STYLE $fly_label_style;
//   #X163:b @TEXT("n108", dx=-0.4, dy=-0.25, halign="end") => @SET-STYLE $fly_label_style;
//   #X163:y @TEXT("n68", dx=0.4, dy=-0.25, halign="start") => @SET-STYLE $fly_label_style;
//   #X164:a @TEXT("measured3", dx=-0.4, dy=-0.25, halign="end") => @SET-STYLE $fly_label_style;
//   #X164:b @TEXT("n109", dx=-0.4, dy=-0.25, halign="end") => @SET-STYLE $fly_label_style;
//   #X164:y @TEXT("n66", dx=0.4, dy=-0.25, halign="start") => @SET-STYLE $fly_label_style;
//   #X165:a @TEXT("measured4", dx=-0.4, dy=-0.25, halign="end") => @SET-STYLE $fly_label_style;
//   #X165:b @TEXT("n106", dx=-0.4, dy=-0.25, halign="end") => @SET-STYLE $fly_label_style;
//   #X165:y @TEXT("n64", dx=0.4, dy=-0.25, halign="start") => @SET-STYLE $fly_label_style;
//   #X166:a @TEXT("measured5", dx=-0.4, dy=-0.25, halign="end") => @SET-STYLE $fly_label_style;
//   #X166:b @TEXT("n107", dx=-0.4, dy=-0.25, halign="end") => @SET-STYLE $fly_label_style;
//   #X166:y @TEXT("n125", dx=0.4, dy=-0.25, halign="start") => @SET-STYLE $fly_label_style;
//   #X167:a @TEXT("measured6", dx=-0.4, dy=-0.25, halign="end") => @SET-STYLE $fly_label_style;
//   #X167:b @TEXT("n115", dx=-0.4, dy=-0.25, halign="end") => @SET-STYLE $fly_label_style;
//   #X167:y @TEXT("n127", dx=0.4, dy=-0.25, halign="start") => @SET-STYLE $fly_label_style;
//   #X168:a @TEXT("measured7", dx=-0.4, dy=-0.25, halign="end") => @SET-STYLE $fly_label_style;
//   #X168:b @TEXT("n116", dx=-0.4, dy=-0.25, halign="end") => @SET-STYLE $fly_label_style;
//   #X168:y @TEXT("n129", dx=0.4, dy=-0.25, halign="start") => @SET-STYLE $fly_label_style;
//   #X169:a @TEXT("measured8", dx=-0.4, dy=-0.25, halign="end") => @SET-STYLE $fly_label_style;
//   #X169:b @TEXT("n113", dx=-0.4, dy=-0.25, halign="end") => @SET-STYLE $fly_label_style;
//   #X169:y @TEXT("n132", dx=0.4, dy=-0.25, halign="start") => @SET-STYLE $fly_label_style;
//   #X170:a @TEXT("measured9", dx=-0.4, dy=-0.25, halign="end") => @SET-STYLE $fly_label_style;
//   #X170:b @TEXT("n124", dx=-0.4, dy=-0.25, halign="end") => @SET-STYLE $fly_label_style;
//   #X170:y @TEXT("n135", dx=0.4, dy=-0.25, halign="start") => @SET-STYLE $fly_label_style;
//   #X171:a @TEXT("measured10", dx=-0.4, dy=-0.25, halign="end") => @SET-STYLE $fly_label_style;
//   #X171:b @TEXT("n110", dx=-0.4, dy=-0.25, halign="end") => @SET-STYLE $fly_label_style;
//   #X171:y @TEXT("n137", dx=0.4, dy=-0.25, halign="start") => @SET-STYLE $fly_label_style;
//   #X172:a @TEXT("measured11", dx=-0.4, dy=-0.25, halign="end") => @SET-STYLE $fly_label_style;
//   #X172:b @TEXT("n111", dx=-0.4, dy=-0.25, halign="end") => @SET-STYLE $fly_label_style;
//   #X172:y @TEXT("n70", dx=0.4, dy=-0.25, halign="start") => @SET-STYLE $fly_label_style;
//   #X173:a @TEXT("measured12", dx=-0.4, dy=-0.25, halign="end") => @SET-STYLE $fly_label_style;
//   #X173:b @TEXT("n118", dx=-0.4, dy=-0.25, halign="end") => @SET-STYLE $fly_label_style;
//   #X173:y @TEXT("n74", dx=0.4, dy=-0.25, halign="start") => @SET-STYLE $fly_label_style;
//   #X174:a @TEXT("measured13", dx=-0.4, dy=-0.25, halign="end") => @SET-STYLE $fly_label_style;
//   #X174:b @TEXT("n119", dx=-0.4, dy=-0.25, halign="end") => @SET-STYLE $fly_label_style;
//   #X174:y @TEXT("n72", dx=0.4, dy=-0.25, halign="start") => @SET-STYLE $fly_label_style;
//   #X175:a @TEXT("n78", dx=-0.4, dy=-0.25, halign="end") => @SET-STYLE $fly_label_style;
//   #X175:b @TEXT("n233", dx=-0.4, dy=-0.25, halign="end") => @SET-STYLE $fly_label_style;
//   #X175:y @TEXT("n234", dx=0.4, dy=-0.25, halign="start") => @SET-STYLE $fly_label_style;
//   #X176:a @TEXT("n234", dx=-0.4, dy=-0.25, halign="end") => @SET-STYLE $fly_label_style;
//   #X176:b @TEXT("n235", dx=-0.4, dy=-0.25, halign="end") => @SET-STYLE $fly_label_style;
//   #X176:y @TEXT("n50", dx=0.4, dy=-0.25, halign="start") => @SET-STYLE $fly_label_style;
//   #X177:a @TEXT("n78", dx=-0.4, dy=-0.25, halign="end") => @SET-STYLE $fly_label_style;
//   #X177:b @TEXT("n236", dx=-0.4, dy=-0.25, halign="end") => @SET-STYLE $fly_label_style;
//   #X177:y @TEXT("n237", dx=0.4, dy=-0.25, halign="start") => @SET-STYLE $fly_label_style;
//   #X178:a @TEXT("n237", dx=-0.4, dy=-0.25, halign="end") => @SET-STYLE $fly_label_style;
//   #X178:b @TEXT("n238", dx=-0.4, dy=-0.25, halign="end") => @SET-STYLE $fly_label_style;
//   #X178:y @TEXT("n52", dx=0.4, dy=-0.25, halign="start") => @SET-STYLE $fly_label_style;
//   #X179:a @TEXT("n78", dx=-0.4, dy=-0.25, halign="end") => @SET-STYLE $fly_label_style;
//   #X179:b @TEXT("n239", dx=-0.4, dy=-0.25, halign="end") => @SET-STYLE $fly_label_style;
//   #X179:y @TEXT("n54", dx=0.4, dy=-0.25, halign="start") => @SET-STYLE $fly_label_style;
//   #X180:a @TEXT("n240", dx=-0.4, dy=-0.25, halign="end") => @SET-STYLE $fly_label_style;
//   #X180:b @TEXT("n36", dx=-0.4, dy=-0.25, halign="end") => @SET-STYLE $fly_label_style;
//   #X180:y @TEXT("n241", dx=0.4, dy=-0.25, halign="start") => @SET-STYLE $fly_label_style;
//   #X181:a @TEXT("n241", dx=-0.4, dy=-0.25, halign="end") => @SET-STYLE $fly_label_style;
//   #X181:b @TEXT("n242", dx=-0.4, dy=-0.25, halign="end") => @SET-STYLE $fly_label_style;
//   #X181:y @TEXT("n243", dx=0.4, dy=-0.25, halign="start") => @SET-STYLE $fly_label_style;
//   #X182:a @TEXT("n243", dx=-0.4, dy=-0.25, halign="end") => @SET-STYLE $fly_label_style;
//   #X182:b @TEXT("n244", dx=-0.4, dy=-0.25, halign="end") => @SET-STYLE $fly_label_style;
//   #X182:y @TEXT("n245", dx=0.4, dy=-0.25, halign="start") => @SET-STYLE $fly_label_style;
//   #X183:a @TEXT("n246", dx=-0.4, dy=-0.25, halign="end") => @SET-STYLE $fly_label_style;
//   #X183:b @TEXT("n40", dx=-0.4, dy=-0.25, halign="end") => @SET-STYLE $fly_label_style;
//   #X183:y @TEXT("n242", dx=0.4, dy=-0.25, halign="start") => @SET-STYLE $fly_label_style;
//   #X184:a @TEXT("n247", dx=-0.4, dy=-0.25, halign="end") => @SET-STYLE $fly_label_style;
//   #X184:b @TEXT("n242", dx=-0.4, dy=-0.25, halign="end") => @SET-STYLE $fly_label_style;
//   #X184:y @TEXT("n248", dx=0.4, dy=-0.25, halign="start") => @SET-STYLE $fly_label_style;
//   #X185:a @TEXT("n248", dx=-0.4, dy=-0.25, halign="end") => @SET-STYLE $fly_label_style;
//   #X185:b @TEXT("n244", dx=-0.4, dy=-0.25, halign="end") => @SET-STYLE $fly_label_style;
//   #X185:y @TEXT("n249", dx=0.4, dy=-0.25, halign="start") => @SET-STYLE $fly_label_style;
//   #X186:a @TEXT("n42", dx=-0.4, dy=-0.25, halign="end") => @SET-STYLE $fly_label_style;
//   #X186:b @TEXT("n250", dx=-0.4, dy=-0.25, halign="end") => @SET-STYLE $fly_label_style;
//   #X186:y @TEXT("n251", dx=0.4, dy=-0.25, halign="start") => @SET-STYLE $fly_label_style;
//   #X187:a @TEXT("n251", dx=-0.4, dy=-0.25, halign="end") => @SET-STYLE $fly_label_style;
//   #X187:b @TEXT("n252", dx=-0.4, dy=-0.25, halign="end") => @SET-STYLE $fly_label_style;
//   #X187:y @TEXT("n244", dx=0.4, dy=-0.25, halign="start") => @SET-STYLE $fly_label_style;
//   #X188:a @TEXT("n253", dx=-0.4, dy=-0.25, halign="end") => @SET-STYLE $fly_label_style;
//   #X188:b @TEXT("n244", dx=-0.4, dy=-0.25, halign="end") => @SET-STYLE $fly_label_style;
//   #X188:y @TEXT("n254", dx=0.4, dy=-0.25, halign="start") => @SET-STYLE $fly_label_style;
//   #X189:a @TEXT("n34", dx=-0.4, dy=-0.25, halign="end") => @SET-STYLE $fly_label_style;
//   #X189:b @TEXT("n255", dx=-0.4, dy=-0.25, halign="end") => @SET-STYLE $fly_label_style;
//   #X189:y @TEXT("n247", dx=0.4, dy=-0.25, halign="start") => @SET-STYLE $fly_label_style;
//   #X190:a @TEXT("n38", dx=-0.4, dy=-0.25, halign="end") => @SET-STYLE $fly_label_style;
//   #X190:b @TEXT("n40", dx=-0.4, dy=-0.25, halign="end") => @SET-STYLE $fly_label_style;
//   #X190:y @TEXT("n256", dx=0.4, dy=-0.25, halign="start") => @SET-STYLE $fly_label_style;
//   #X191:a @TEXT("n42", dx=-0.4, dy=-0.25, halign="end") => @SET-STYLE $fly_label_style;
//   #X191:b @TEXT("n44", dx=-0.4, dy=-0.25, halign="end") => @SET-STYLE $fly_label_style;
//   #X191:y @TEXT("n257", dx=0.4, dy=-0.25, halign="start") => @SET-STYLE $fly_label_style;
//   #X192:a @TEXT("n46", dx=-0.4, dy=-0.25, halign="end") => @SET-STYLE $fly_label_style;
//   #X192:b @TEXT("n48", dx=-0.4, dy=-0.25, halign="end") => @SET-STYLE $fly_label_style;
//   #X192:y @TEXT("n252", dx=0.4, dy=-0.25, halign="start") => @SET-STYLE $fly_label_style;
//   #X193:a @TEXT("n247", dx=-0.4, dy=-0.25, halign="end") => @SET-STYLE $fly_label_style;
//   #X193:b @TEXT("n256", dx=-0.4, dy=-0.25, halign="end") => @SET-STYLE $fly_label_style;
//   #X193:y @TEXT("n253", dx=0.4, dy=-0.25, halign="start") => @SET-STYLE $fly_label_style;
//   #X194:a @TEXT("n257", dx=-0.4, dy=-0.25, halign="end") => @SET-STYLE $fly_label_style;
//   #X194:b @TEXT("n252", dx=-0.4, dy=-0.25, halign="end") => @SET-STYLE $fly_label_style;
//   #X194:y @TEXT("n258", dx=0.4, dy=-0.25, halign="start") => @SET-STYLE $fly_label_style;
//   #X195:a @TEXT("n253", dx=-0.4, dy=-0.25, halign="end") => @SET-STYLE $fly_label_style;
//   #X195:b @TEXT("n258", dx=-0.4, dy=-0.25, halign="end") => @SET-STYLE $fly_label_style;
//   #X195:y @TEXT("n259", dx=0.4, dy=-0.25, halign="start") => @SET-STYLE $fly_label_style;
//   #X196:a @TEXT("n260", dx=-0.4, dy=-0.25, halign="end") => @SET-STYLE $fly_label_style;
//   #X196:b @TEXT("n93", dx=-0.4, dy=-0.25, halign="end") => @SET-STYLE $fly_label_style;
//   #X196:y @TEXT("n221", dx=0.4, dy=-0.25, halign="start") => @SET-STYLE $fly_label_style;
//   #X197:a @TEXT("n261", dx=-0.4, dy=-0.25, halign="end") => @SET-STYLE $fly_label_style;
//   #X197:b @TEXT("n221", dx=-0.4, dy=-0.25, halign="end") => @SET-STYLE $fly_label_style;
//   #X197:y @TEXT("n262", dx=0.4, dy=-0.25, halign="start") => @SET-STYLE $fly_label_style;
//   #X198:a @TEXT("n130", dx=-0.4, dy=-0.25, halign="end") => @SET-STYLE $fly_label_style;
//   #X198:b @TEXT("target_k3", dx=-0.4, dy=-0.25, halign="end") => @SET-STYLE $fly_label_style;
//   #X198:y @TEXT("n97", dx=0.4, dy=-0.25, halign="start") => @SET-STYLE $fly_label_style;
//   #X199:a @TEXT("n100", dx=-0.4, dy=-0.25, halign="end") => @SET-STYLE $fly_label_style;
//   #X199:b @TEXT("target_k5", dx=-0.4, dy=-0.25, halign="end") => @SET-STYLE $fly_label_style;
//   #X199:y @TEXT("n102", dx=0.4, dy=-0.25, halign="start") => @SET-STYLE $fly_label_style;
//   #X200:a @TEXT("n105", dx=-0.4, dy=-0.25, halign="end") => @SET-STYLE $fly_label_style;
//   #X200:b @TEXT("n97", dx=-0.4, dy=-0.25, halign="end") => @SET-STYLE $fly_label_style;
//   #X200:y @TEXT("n260", dx=0.4, dy=-0.25, halign="start") => @SET-STYLE $fly_label_style;
//   #X201:a @TEXT("n260", dx=-0.4, dy=-0.25, halign="end") => @SET-STYLE $fly_label_style;
//   #X201:b @TEXT("n102", dx=-0.4, dy=-0.25, halign="end") => @SET-STYLE $fly_label_style;
//   #X201:y @TEXT("n263", dx=0.4, dy=-0.25, halign="start") => @SET-STYLE $fly_label_style;
//   #X202:a @TEXT("n80", dx=-0.4, dy=-0.25, halign="end") => @SET-STYLE $fly_label_style;
//   #X202:b @TEXT("n263", dx=-0.4, dy=-0.25, halign="end") => @SET-STYLE $fly_label_style;
//   #X202:y @TEXT("n264", dx=0.4, dy=-0.25, halign="start") => @SET-STYLE $fly_label_style;
//   #X203:a @TEXT("measured0", dx=-0.4, dy=-0.25, halign="end") => @SET-STYLE $fly_label_style;
//   #X203:b @TEXT("n63", dx=-0.4, dy=-0.25, halign="end") => @SET-STYLE $fly_label_style;
//   #X203:y @TEXT("n265", dx=0.4, dy=-0.25, halign="start") => @SET-STYLE $fly_label_style;
//   #X204:a @TEXT("n65", dx=-0.4, dy=-0.25, halign="end") => @SET-STYLE $fly_label_style;
//   #X204:b @TEXT("n139", dx=-0.4, dy=-0.25, halign="end") => @SET-STYLE $fly_label_style;
//   #X204:y @TEXT("n266", dx=0.4, dy=-0.25, halign="start") => @SET-STYLE $fly_label_style;
//   #X205:a @TEXT("n140", dx=-0.4, dy=-0.25, halign="end") => @SET-STYLE $fly_label_style;
//   #X205:b @TEXT("n141", dx=-0.4, dy=-0.25, halign="end") => @SET-STYLE $fly_label_style;
//   #X205:y @TEXT("n164", dx=0.4, dy=-0.25, halign="start") => @SET-STYLE $fly_label_style;
//   #X206:a @TEXT("n75", dx=-0.4, dy=-0.25, halign="end") => @SET-STYLE $fly_label_style;
//   #X206:b @TEXT("n73", dx=-0.4, dy=-0.25, halign="end") => @SET-STYLE $fly_label_style;
//   #X206:y @TEXT("n148", dx=0.4, dy=-0.25, halign="start") => @SET-STYLE $fly_label_style;
//   #X207:a @TEXT("n265", dx=-0.4, dy=-0.25, halign="end") => @SET-STYLE $fly_label_style;
//   #X207:b @TEXT("n167", dx=-0.4, dy=-0.25, halign="end") => @SET-STYLE $fly_label_style;
//   #X207:y @TEXT("n267", dx=0.4, dy=-0.25, halign="start") => @SET-STYLE $fly_label_style;
//   #X208:a @TEXT("n266", dx=-0.4, dy=-0.25, halign="end") => @SET-STYLE $fly_label_style;
//   #X208:b @TEXT("n164", dx=-0.4, dy=-0.25, halign="end") => @SET-STYLE $fly_label_style;
//   #X208:y @TEXT("n156", dx=0.4, dy=-0.25, halign="start") => @SET-STYLE $fly_label_style;
//   #X209:a @TEXT("n170", dx=-0.4, dy=-0.25, halign="end") => @SET-STYLE $fly_label_style;
//   #X209:b @TEXT("n160", dx=-0.4, dy=-0.25, halign="end") => @SET-STYLE $fly_label_style;
//   #X209:y @TEXT("n152", dx=0.4, dy=-0.25, halign="start") => @SET-STYLE $fly_label_style;
//   #X210:a @TEXT("n267", dx=-0.4, dy=-0.25, halign="end") => @SET-STYLE $fly_label_style;
//   #X210:b @TEXT("n156", dx=-0.4, dy=-0.25, halign="end") => @SET-STYLE $fly_label_style;
//   #X210:y @TEXT("n268", dx=0.4, dy=-0.25, halign="start") => @SET-STYLE $fly_label_style;
//   #X211:a @TEXT("n152", dx=-0.4, dy=-0.25, halign="end") => @SET-STYLE $fly_label_style;
//   #X211:b @TEXT("n148", dx=-0.4, dy=-0.25, halign="end") => @SET-STYLE $fly_label_style;
//   #X211:y @TEXT("n269", dx=0.4, dy=-0.25, halign="start") => @SET-STYLE $fly_label_style;
//   #X212:a @TEXT("n268", dx=-0.4, dy=-0.25, halign="end") => @SET-STYLE $fly_label_style;
//   #X212:b @TEXT("n269", dx=-0.4, dy=-0.25, halign="end") => @SET-STYLE $fly_label_style;
//   #X212:y @TEXT("n224", dx=0.4, dy=-0.25, halign="start") => @SET-STYLE $fly_label_style;
//   #X213:a @TEXT("n270", dx=-0.4, dy=-0.25, halign="end") => @SET-STYLE $fly_label_style;
//   #X213:b @TEXT("n224", dx=-0.4, dy=-0.25, halign="end") => @SET-STYLE $fly_label_style;
//   #X213:y @TEXT("n271", dx=0.4, dy=-0.25, halign="start") => @SET-STYLE $fly_label_style;
//   #X214:a @TEXT("n58", dx=-0.4, dy=-0.25, halign="end") => @SET-STYLE $fly_label_style;
//   #X214:b @TEXT("n57", dx=-0.4, dy=-0.25, halign="end") => @SET-STYLE $fly_label_style;
//   #X214:y @TEXT("n210", dx=0.4, dy=-0.25, halign="start") => @SET-STYLE $fly_label_style;
//   #X215:a @TEXT("n186", dx=-0.4, dy=-0.25, halign="end") => @SET-STYLE $fly_label_style;
//   #X215:b @TEXT("n59", dx=-0.4, dy=-0.25, halign="end") => @SET-STYLE $fly_label_style;
//   #X215:y @TEXT("n202", dx=0.4, dy=-0.25, halign="start") => @SET-STYLE $fly_label_style;
//   #X216:a @TEXT("n61", dx=-0.4, dy=-0.25, halign="end") => @SET-STYLE $fly_label_style;
//   #X216:b @TEXT("n60", dx=-0.4, dy=-0.25, halign="end") => @SET-STYLE $fly_label_style;
//   #X216:y @TEXT("n190", dx=0.4, dy=-0.25, halign="start") => @SET-STYLE $fly_label_style;
//   #X217:a @TEXT("n220", dx=-0.4, dy=-0.25, halign="end") => @SET-STYLE $fly_label_style;
//   #X217:b @TEXT("n210", dx=-0.4, dy=-0.25, halign="end") => @SET-STYLE $fly_label_style;
//   #X217:y @TEXT("n272", dx=0.4, dy=-0.25, halign="start") => @SET-STYLE $fly_label_style;
//   #X218:a @TEXT("n217", dx=-0.4, dy=-0.25, halign="end") => @SET-STYLE $fly_label_style;
//   #X218:b @TEXT("n206", dx=-0.4, dy=-0.25, halign="end") => @SET-STYLE $fly_label_style;
//   #X218:y @TEXT("n198", dx=0.4, dy=-0.25, halign="start") => @SET-STYLE $fly_label_style;
//   #X219:a @TEXT("n214", dx=-0.4, dy=-0.25, halign="end") => @SET-STYLE $fly_label_style;
//   #X219:b @TEXT("n202", dx=-0.4, dy=-0.25, halign="end") => @SET-STYLE $fly_label_style;
//   #X219:y @TEXT("n194", dx=0.4, dy=-0.25, halign="start") => @SET-STYLE $fly_label_style;
//   #X220:a @TEXT("n272", dx=-0.4, dy=-0.25, halign="end") => @SET-STYLE $fly_label_style;
//   #X220:b @TEXT("n198", dx=-0.4, dy=-0.25, halign="end") => @SET-STYLE $fly_label_style;
//   #X220:y @TEXT("n273", dx=0.4, dy=-0.25, halign="start") => @SET-STYLE $fly_label_style;
//   #X221:a @TEXT("n194", dx=-0.4, dy=-0.25, halign="end") => @SET-STYLE $fly_label_style;
//   #X221:b @TEXT("n190", dx=-0.4, dy=-0.25, halign="end") => @SET-STYLE $fly_label_style;
//   #X221:y @TEXT("n274", dx=0.4, dy=-0.25, halign="start") => @SET-STYLE $fly_label_style;
//   #X222:a @TEXT("n273", dx=-0.4, dy=-0.25, halign="end") => @SET-STYLE $fly_label_style;
//   #X222:b @TEXT("n274", dx=-0.4, dy=-0.25, halign="end") => @SET-STYLE $fly_label_style;
//   #X222:y @TEXT("n275", dx=0.4, dy=-0.25, halign="start") => @SET-STYLE $fly_label_style;
//   #X223:a @TEXT("n276", dx=-0.4, dy=-0.25, halign="end") => @SET-STYLE $fly_label_style;
//   #X223:b @TEXT("n275", dx=-0.4, dy=-0.25, halign="end") => @SET-STYLE $fly_label_style;
//   #X223:y @TEXT("n277", dx=0.4, dy=-0.25, halign="start") => @SET-STYLE $fly_label_style;
//   #X224:a @TEXT("n233", dx=-0.4, dy=-0.25, halign="end") => @SET-STYLE $fly_label_style;
//   #X224:b @TEXT("n235", dx=-0.4, dy=-0.25, halign="end") => @SET-STYLE $fly_label_style;
//   #X224:y @TEXT("n278", dx=0.4, dy=-0.25, halign="start") => @SET-STYLE $fly_label_style;
//   #X225:a @TEXT("n34", dx=-0.4, dy=-0.25, halign="end") => @SET-STYLE $fly_label_style;
//   #X225:b @TEXT("n36", dx=-0.4, dy=-0.25, halign="end") => @SET-STYLE $fly_label_style;
//   #X225:y @TEXT("n279", dx=0.4, dy=-0.25, halign="start") => @SET-STYLE $fly_label_style;
//   #X226:a @TEXT("n279", dx=-0.4, dy=-0.25, halign="end") => @SET-STYLE $fly_label_style;
//   #X226:b @TEXT("n256", dx=-0.4, dy=-0.25, halign="end") => @SET-STYLE $fly_label_style;
//   #X226:y @TEXT("n280", dx=0.4, dy=-0.25, halign="start") => @SET-STYLE $fly_label_style;
//   #X227:a @TEXT("n280", dx=-0.4, dy=-0.25, halign="end") => @SET-STYLE $fly_label_style;
//   #X227:b @TEXT("n258", dx=-0.4, dy=-0.25, halign="end") => @SET-STYLE $fly_label_style;
//   #X227:y @TEXT("n281", dx=0.4, dy=-0.25, halign="start") => @SET-STYLE $fly_label_style;
//   #X228:a @TEXT("n236", dx=-0.4, dy=-0.25, halign="end") => @SET-STYLE $fly_label_style;
//   #X228:b @TEXT("n238", dx=-0.4, dy=-0.25, halign="end") => @SET-STYLE $fly_label_style;
//   #X228:y @TEXT("n282", dx=0.4, dy=-0.25, halign="start") => @SET-STYLE $fly_label_style;
//   #X229:a @TEXT("n245", dx=-0.4, dy=-0.25, halign="end") => @SET-STYLE $fly_label_style;
//   #X229:y @TEXT("n239", dx=0.4, dy=-0.25, halign="start") => @SET-STYLE $fly_label_style;
//   #X230:a @TEXT("n249", dx=-0.4, dy=-0.25, halign="end") => @SET-STYLE $fly_label_style;
//   #X230:y @TEXT("n233", dx=0.4, dy=-0.25, halign="start") => @SET-STYLE $fly_label_style;
//   #X231:a @TEXT("n281", dx=-0.4, dy=-0.25, halign="end") => @SET-STYLE $fly_label_style;
//   #X231:y @TEXT("n235", dx=0.4, dy=-0.25, halign="start") => @SET-STYLE $fly_label_style;
//   #X232:a @TEXT("n254", dx=-0.4, dy=-0.25, halign="end") => @SET-STYLE $fly_label_style;
//   #X232:y @TEXT("n236", dx=0.4, dy=-0.25, halign="start") => @SET-STYLE $fly_label_style;
//   #X233:a @TEXT("n259", dx=-0.4, dy=-0.25, halign="end") => @SET-STYLE $fly_label_style;
//   #X233:y @TEXT("n238", dx=0.4, dy=-0.25, halign="start") => @SET-STYLE $fly_label_style;
//   #X234:a @TEXT("n262", dx=-0.4, dy=-0.25, halign="end") => @SET-STYLE $fly_label_style;
//   #X234:b @TEXT("n264", dx=-0.4, dy=-0.25, halign="end") => @SET-STYLE $fly_label_style;
//   #X234:y @TEXT("n283", dx=0.4, dy=-0.25, halign="start") => @SET-STYLE $fly_label_style;
//   #X235:a @TEXT("n283", dx=-0.4, dy=-0.25, halign="end") => @SET-STYLE $fly_label_style;
//   #X235:b @TEXT("n271", dx=-0.4, dy=-0.25, halign="end") => @SET-STYLE $fly_label_style;
//   #X235:y @TEXT("n284", dx=0.4, dy=-0.25, halign="start") => @SET-STYLE $fly_label_style;
//   #X236:a @TEXT("n284", dx=-0.4, dy=-0.25, halign="end") => @SET-STYLE $fly_label_style;
//   #X236:b @TEXT("n277", dx=-0.4, dy=-0.25, halign="end") => @SET-STYLE $fly_label_style;
//   #X236:y @TEXT("n285", dx=0.4, dy=-0.25, halign="start") => @SET-STYLE $fly_label_style;
//   #X237:b @TEXT("n239", dx=-0.4, dy=-0.25, halign="end") => @SET-STYLE $fly_label_style;
//   #X237:s @TEXT("active", dx=0, dy=-1.0, halign="middle") => @SET-STYLE $fly_label_style;
//   #X237:y @TEXT("n32", dx=0.4, dy=-0.25, halign="start") => @SET-STYLE $fly_label_style;
//   #X238:b @TEXT("n240", dx=-0.4, dy=-0.25, halign="end") => @SET-STYLE $fly_label_style;
//   #X238:s @TEXT("active", dx=0, dy=-1.0, halign="middle") => @SET-STYLE $fly_label_style;
//   #X238:y @TEXT("n33", dx=0.4, dy=-0.25, halign="start") => @SET-STYLE $fly_label_style;
//   #X239:b @TEXT("n226", dx=-0.4, dy=-0.25, halign="end") => @SET-STYLE $fly_label_style;
//   #X239:s @TEXT("active", dx=0, dy=-1.0, halign="middle") => @SET-STYLE $fly_label_style;
//   #X239:y @TEXT("n35", dx=0.4, dy=-0.25, halign="start") => @SET-STYLE $fly_label_style;
//   #X240:b @TEXT("n227", dx=-0.4, dy=-0.25, halign="end") => @SET-STYLE $fly_label_style;
//   #X240:s @TEXT("active", dx=0, dy=-1.0, halign="middle") => @SET-STYLE $fly_label_style;
//   #X240:y @TEXT("n37", dx=0.4, dy=-0.25, halign="start") => @SET-STYLE $fly_label_style;
//   #X241:b @TEXT("n228", dx=-0.4, dy=-0.25, halign="end") => @SET-STYLE $fly_label_style;
//   #X241:s @TEXT("active", dx=0, dy=-1.0, halign="middle") => @SET-STYLE $fly_label_style;
//   #X241:y @TEXT("n39", dx=0.4, dy=-0.25, halign="start") => @SET-STYLE $fly_label_style;
//   #X242:b @TEXT("n229", dx=-0.4, dy=-0.25, halign="end") => @SET-STYLE $fly_label_style;
//   #X242:s @TEXT("active", dx=0, dy=-1.0, halign="middle") => @SET-STYLE $fly_label_style;
//   #X242:y @TEXT("n41", dx=0.4, dy=-0.25, halign="start") => @SET-STYLE $fly_label_style;
//   #X243:b @TEXT("n230", dx=-0.4, dy=-0.25, halign="end") => @SET-STYLE $fly_label_style;
//   #X243:s @TEXT("active", dx=0, dy=-1.0, halign="middle") => @SET-STYLE $fly_label_style;
//   #X243:y @TEXT("n43", dx=0.4, dy=-0.25, halign="start") => @SET-STYLE $fly_label_style;
//   #X244:b @TEXT("n231", dx=-0.4, dy=-0.25, halign="end") => @SET-STYLE $fly_label_style;
//   #X244:s @TEXT("active", dx=0, dy=-1.0, halign="middle") => @SET-STYLE $fly_label_style;
//   #X244:y @TEXT("n45", dx=0.4, dy=-0.25, halign="start") => @SET-STYLE $fly_label_style;
//   #X245:b @TEXT("n232", dx=-0.4, dy=-0.25, halign="end") => @SET-STYLE $fly_label_style;
//   #X245:s @TEXT("active", dx=0, dy=-1.0, halign="middle") => @SET-STYLE $fly_label_style;
//   #X245:y @TEXT("n47", dx=0.4, dy=-0.25, halign="start") => @SET-STYLE $fly_label_style;
//   #X246:a @TEXT("n285", dx=-0.4, dy=-0.25, halign="end") => @SET-STYLE $fly_label_style;
//   #X246:b @TEXT("nx", dx=-0.4, dy=-0.25, halign="end") => @SET-STYLE $fly_label_style;
//   #X246:s @TEXT("n245", dx=0, dy=-1.0, halign="middle") => @SET-STYLE $fly_label_style;
//   #X246:y @TEXT("n286", dx=0.4, dy=-0.25, halign="start") => @SET-STYLE $fly_label_style;
//   #X247:b @TEXT("n286", dx=-0.4, dy=-0.25, halign="end") => @SET-STYLE $fly_label_style;
//   #X247:s @TEXT("active", dx=0, dy=-1.0, halign="middle") => @SET-STYLE $fly_label_style;
//   #X247:y @TEXT("n53", dx=0.4, dy=-0.25, halign="start") => @SET-STYLE $fly_label_style;
//   #X248:b @TEXT("n287", dx=-0.4, dy=-0.25, halign="end") => @SET-STYLE $fly_label_style;
//   #X248:s @TEXT("active", dx=0, dy=-1.0, halign="middle") => @SET-STYLE $fly_label_style;
//   #X248:y @TEXT("n49", dx=0.4, dy=-0.25, halign="start") => @SET-STYLE $fly_label_style;
//   #X249:b @TEXT("n288", dx=-0.4, dy=-0.25, halign="end") => @SET-STYLE $fly_label_style;
//   #X249:s @TEXT("active", dx=0, dy=-1.0, halign="middle") => @SET-STYLE $fly_label_style;
//   #X249:y @TEXT("n51", dx=0.4, dy=-0.25, halign="start") => @SET-STYLE $fly_label_style;
//   #X250:a @TEXT("target_k2", dx=-0.4, dy=-0.25, halign="end") => @SET-STYLE $fly_label_style;
//   #X250:y @TEXT("n130", dx=0.4, dy=-0.25, halign="start") => @SET-STYLE $fly_label_style;
//   #X251:a @TEXT("target_k3", dx=-0.4, dy=-0.25, halign="end") => @SET-STYLE $fly_label_style;
//   #X251:y @TEXT("n133", dx=0.4, dy=-0.25, halign="start") => @SET-STYLE $fly_label_style;
//   #X252:a @TEXT("target_k4", dx=-0.4, dy=-0.25, halign="end") => @SET-STYLE $fly_label_style;
//   #X252:y @TEXT("n100", dx=0.4, dy=-0.25, halign="start") => @SET-STYLE $fly_label_style;
//   #X253:a @TEXT("target_k5", dx=-0.4, dy=-0.25, halign="end") => @SET-STYLE $fly_label_style;
//   #X253:y @TEXT("n99", dx=0.4, dy=-0.25, halign="start") => @SET-STYLE $fly_label_style;
//   #X254:a @TEXT("n222", dx=-0.4, dy=-0.25, halign="end") => @SET-STYLE $fly_label_style;
//   #X254:y @TEXT("n261", dx=0.4, dy=-0.25, halign="start") => @SET-STYLE $fly_label_style;
//   #X255:a @TEXT("n225", dx=-0.4, dy=-0.25, halign="end") => @SET-STYLE $fly_label_style;
//   #X255:y @TEXT("n270", dx=0.4, dy=-0.25, halign="start") => @SET-STYLE $fly_label_style;
//   #X256:a @TEXT("n147", dx=-0.4, dy=-0.25, halign="end") => @SET-STYLE $fly_label_style;
//   #X256:y @TEXT("n223", dx=0.4, dy=-0.25, halign="start") => @SET-STYLE $fly_label_style;
//   #X257:a @TEXT("n189", dx=-0.4, dy=-0.25, halign="end") => @SET-STYLE $fly_label_style;
//   #X257:y @TEXT("n276", dx=0.4, dy=-0.25, halign="start") => @SET-STYLE $fly_label_style;
//   #X258:a @TEXT("n34", dx=-0.4, dy=-0.25, halign="end") => @SET-STYLE $fly_label_style;
//   #X258:y @TEXT("n240", dx=0.4, dy=-0.25, halign="start") => @SET-STYLE $fly_label_style;
//   #X259:a @TEXT("n36", dx=-0.4, dy=-0.25, halign="end") => @SET-STYLE $fly_label_style;
//   #X259:y @TEXT("n255", dx=0.4, dy=-0.25, halign="start") => @SET-STYLE $fly_label_style;
//   #X260:a @TEXT("n38", dx=-0.4, dy=-0.25, halign="end") => @SET-STYLE $fly_label_style;
//   #X260:y @TEXT("n246", dx=0.4, dy=-0.25, halign="start") => @SET-STYLE $fly_label_style;
//   #X261:a @TEXT("n44", dx=-0.4, dy=-0.25, halign="end") => @SET-STYLE $fly_label_style;
//   #X261:y @TEXT("n250", dx=0.4, dy=-0.25, halign="start") => @SET-STYLE $fly_label_style;
//   #X262:a @TEXT("nx", dx=-0.4, dy=-0.25, halign="end") => @SET-STYLE $fly_label_style;
//   #X262:b @TEXT("n233", dx=-0.4, dy=-0.25, halign="end") => @SET-STYLE $fly_label_style;
//   #X262:s @TEXT("n278", dx=0, dy=-1.0, halign="middle") => @SET-STYLE $fly_label_style;
//   #X262:y @TEXT("n287", dx=0.4, dy=-0.25, halign="start") => @SET-STYLE $fly_label_style;
//   #X263:a @TEXT("nx", dx=-0.4, dy=-0.25, halign="end") => @SET-STYLE $fly_label_style;
//   #X263:b @TEXT("n238", dx=-0.4, dy=-0.25, halign="end") => @SET-STYLE $fly_label_style;
//   #X263:s @TEXT("n282", dx=0, dy=-1.0, halign="middle") => @SET-STYLE $fly_label_style;
//   #X263:y @TEXT("n288", dx=0.4, dy=-0.25, halign="start") => @SET-STYLE $fly_label_style;
//
//   /* --- 4. Architectural Section Frames & Annotations --- */
//   (24, 80) @RECTANGLE(width=12, height=156) => @SET-STYLE $section_box;
//   (24, 159.5) @TEXT("State Registers (12 DFFs)", halign="middle") => @SET-STYLE $section_label;
//   (48, 80) @RECTANGLE(width=12, height=156) => @SET-STYLE $section_box;
//   (48, 159.5) @TEXT("Datapath Multiplexers (18 MUX2)", halign="middle") => @SET-STYLE $section_label;
//   (168, 80) @RECTANGLE(width=204, height=156) => @SET-STYLE $section_box;
//   (168, 159.5) @TEXT("Combinational Logic Cloud (234 Gates)", halign="middle") => @SET-STYLE $section_label;
//   (142, 166) @TEXT("tx_frequency_watchdog_pdk110_80: Synthesized Continuous Frequency-Drift Watchdog Monitor (264 Gates)", halign="middle") => @SET-STYLE $title_style;
//   (142, 163.5) @TEXT("Single-Line Buses (TARGET_K<5:0>, MEASURED<13:0>) + Flying-Wire Terminal Labels Across State DFFs, MUXes & Logic Cloud", halign="middle") => @SET-STYLE $subtitle_style;
//   (142, -5) @RECTANGLE(width=276, height=5.0) => @SET-STYLE $defect_box;
//   (142, -3.8) @TEXT("DEFECT: Undriven Floating Net 'nx' Feeds Input a of 3 Multiplexers (X246, X262, X263)", halign="middle") => @SET-STYLE $defect_style;
//   (142, -6.0) @TEXT("Net 'nx' has zero drivers in tx_frequency_watchdog_pdk110_80; synthesis hi/lo tie emission bug leaves mux input a floating (tie nx to vss/vdd)", halign="middle") => @SET-STYLE $param_style
// }
ends tx_frequency_watchdog_pdk110_80
