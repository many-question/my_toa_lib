simulator lang=spectre
// @RNL(type="header") { @USE-PACKAGE(name="rnl-std-all", version="0.4"); @USE-PACKAGE(name="rnl-std-semantics", version="0.4");
//   @VERSION("0.4");
//   @USE-PACKAGE(name="pll-semantics/tx_dff_r1_pdk110_70", version="0.3", path="pll_semantics.rnl");
//   @USE-PACKAGE(name="pll-inv-pdk110-48-sym", version="0.1");
//   @USE-PACKAGE(name="pll-inv-pdk110-62-sym", version="0.1");
//   @USE-PACKAGE(name="tx-dff-r0-pdk110-58-sym", version="0.1")
// }
// @RNL { # @SELECT-PIN(recursive=true) => @REMOVE-FROM $LABEL_FILL_SET; $SUPPLY_NET_SET @REMOVE-FROM $PORT_FILL_SET; $GROUND_NET_SET @REMOVE-FROM $PORT_FILL_SET }
subckt tx_dff_r1_pdk110_70 (d clk reset q vdd vss)
XI (d db vdd vss) pll_inv_pdk110_48
XF (db clk reset qb vdd vss) tx_dff_r0_pdk110_58
XO (qb q vdd vss) pll_inv_pdk110_62
// @RNL(author="gemini-4-argon") {
//
//   /* --- 1. Circuit Semantics --- */
//   %dff = {#XF}(master_latch) {#XI #XO}(output_buffers) @AS(edge="rising", async_reset="active_high_preset_to_1") $MASTER_SLAVE_DFF;
//   {%pd #XI #XF #XO %pq} @AS $SIGNAL_FLOW; {%pd #XI #XF #XO %pq} @ORDER("left-to-right", priority="low");
//
//   /* --- 2. Schematic Placement & Orientation --- */
//   %pd   = $IO_PORT @ATTACH &d     => @PLACE(2, 13)  => @ORIENT("R0");
//   %pclk = $IO_PORT @ATTACH &clk   => @PLACE(2, 11)  => @ORIENT("R0");
//   %prst = $IO_PORT @ATTACH &reset => @PLACE(2, 6)   => @ORIENT("R0");
//   %pq   = $IO_PORT @ATTACH &q     => @PLACE(36, 12) => @ORIENT("MY");
//
//   #XI @PLACE(9, 13)  => @ORIENT("R0");
//   #XF @PLACE(20, 12) => @ORIENT("R0");
//   #XO @PLACE(30, 12) => @ORIENT("R0");
//
//   /* --- 3. Explicit Manhattan Wiring --- */
//   &d     @WIRE { %pd::pin #XI:a };
//   &db    @WIRE { #XI:y #XF:d };
//   &clk   @WIRE { %pclk::pin #XF:clk };
//   &reset @WIRE { %prst::pin (20, 6) #XF:reset };
//   &qb    @WIRE { #XF:q #XO:a };
//   &q     @WIRE { #XO:y %pq::pin };
//
//   /* --- 4. Annotations --- */
//   (19, 19) @TEXT("tx_dff_r1_pdk110_70: Rising-Edge D Flip-Flop with Asynchronous Preset to 1 (reset=1 -> q=1)", halign="middle") => @SET-STYLE $title_style;
//   (19, 17.3) @TEXT("Inverts D Input (XI) and Q Output (XO) Around Clear-to-0 DFF (XF: tx_dff_r0) to Realize Preset-to-1", halign="middle") => @SET-STYLE $subtitle_style
// }
ends tx_dff_r1_pdk110_70
