simulator lang=spectre
// @RNL(type="header") { @USE-PACKAGE(name="rnl-std-all", version="0.4"); @USE-PACKAGE(name="rnl-std-semantics", version="0.4");
//   @VERSION("0.4");
//   @USE-PACKAGE(name="pll-semantics/tx_xor_pdk110_66", version="0.3", path="pll_semantics.rnl");
//   @USE-PACKAGE(name="pll-inv-pdk110-48-sym", version="0.1");
//   @USE-PACKAGE(name="tx-mux-pdk110-64-sym", version="0.1")
// }
// @RNL { # @SELECT-PIN(recursive=true) => @REMOVE-FROM $LABEL_FILL_SET; $SUPPLY_NET_SET @REMOVE-FROM $PORT_FILL_SET; $GROUND_NET_SET @REMOVE-FROM $PORT_FILL_SET }
subckt tx_xor_pdk110_66 (a b y vdd vss)
XI (a ab vdd vss) pll_inv_pdk110_48
XM (a ab b y vdd vss) tx_mux_pdk110_64
// @RNL(author="gemini-4-argon") {
//
//   /* --- 1. Circuit Semantics --- */
//   %mux = {#XM}(mux_cells) @AS(role="xor_via_2to1_mux") $MULTIPLEXER_BANK;
//   {%pa #XI #XM %py} @AS $SIGNAL_FLOW; {%pa #XI #XM %py} @ORDER("left-to-right", priority="low");
//
//   /* --- 2. Schematic Placement & Orientation --- */
//   %pa = $IO_PORT @ATTACH &a => @PLACE(2, 13)  => @ORIENT("R0");
//   %pb = $IO_PORT @ATTACH &b => @PLACE(2, 6)   => @ORIENT("R0");
//   %py = $IO_PORT @ATTACH &y => @PLACE(28, 12) => @ORIENT("MY");
//
//   #XI @PLACE(11, 11) => @ORIENT("R0");
//   #XM @PLACE(20, 12) => @ORIENT("R0");
//
//   /* --- 3. Explicit Manhattan Wiring --- */
//   %ja = (5, 13);
//   $JUNCTION @ATTACH %ja;
//   &a  @WIRE { %pa::pin %ja #XM:a };
//   &a  @WIRE { %ja (5, 11) #XI:a };
//   &ab @WIRE { #XI:y #XM:b };
//   &b  @WIRE { %pb::pin (20, 6) #XM:s };
//   &y  @WIRE { #XM:y %py::pin };
//
//   /* --- 4. Annotations --- */
//   (15, 18) @TEXT("tx_xor_pdk110_66: 2-Input Exclusive-OR Gate (212 Instances in Arithmetic/Comparators)", halign="middle") => @SET-STYLE $title_style;
//   (15, 16.3) @TEXT("Implemented as 2-to-1 Multiplexer (XM): Selects a when b=0, or NOT(a) (via XI) when b=1", halign="middle") => @SET-STYLE $subtitle_style
// }
ends tx_xor_pdk110_66
