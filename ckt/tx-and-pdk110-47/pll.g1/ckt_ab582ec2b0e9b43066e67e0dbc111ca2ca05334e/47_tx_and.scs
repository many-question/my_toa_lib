simulator lang=spectre
// @RNL(type="header") { @USE-PACKAGE(name="rnl-std-all", version="0.4"); @USE-PACKAGE(name="rnl-std-semantics", version="0.4");
//   @VERSION("0.4");
//   @USE-PACKAGE(name="pll-semantics/tx_and_pdk110_47", version="0.3", path="pll_semantics.rnl");
//   @USE-PACKAGE(name="pll-inv-pdk110-48-sym", version="0.1");
//   @USE-PACKAGE(name="pll-nand2-pdk110-15-sym", version="0.1")
// }
// @RNL { # @SELECT-PIN(recursive=true) => @REMOVE-FROM $LABEL_FILL_SET; $SUPPLY_NET_SET @REMOVE-FROM $PORT_FILL_SET; $GROUND_NET_SET @REMOVE-FROM $PORT_FILL_SET }
subckt tx_and_pdk110_47 (a b y vdd vss)
XN (a b n vdd vss) pll_nand2_pdk110_15
XI (n y vdd vss) pll_inv_pdk110_48
// @RNL(author="gemini-4-argon") {
//
//   /* --- 1. Circuit Semantics --- */
//   {%pa #XN #XI %py} @AS $SIGNAL_FLOW; {%pa #XN #XI %py} @ORDER("left-to-right", priority="low");
//
//   /* --- 2. Schematic Placement & Orientation --- */
//   %pa = $IO_PORT @ATTACH &a => @PLACE(2, 11) => @ORIENT("R0");
//   %pb = $IO_PORT @ATTACH &b => @PLACE(2, 9)  => @ORIENT("R0");
//   %py = $IO_PORT @ATTACH &y => @PLACE(26, 10) => @ORIENT("MY");
//
//   #XN @PLACE(10, 10) => @ORIENT("R0");
//   #XI @PLACE(20, 10) => @ORIENT("R0");
//
//   /* --- 3. Explicit Manhattan Wiring --- */
//   &a @WIRE { %pa::pin #XN:a };
//   &b @WIRE { %pb::pin #XN:b };
//   &n @WIRE { #XN:y #XI:a };
//   &y @WIRE { #XI:y %py::pin };
//
//   /* --- 4. Annotations --- */
//   (14, 16) @TEXT("tx_and_pdk110_47: 2-Input Static CMOS AND Gate (650 Instances in Synthesized Logic)", halign="middle") => @SET-STYLE $title_style;
//   (14, 14.3) @TEXT("2-Input NAND Gate (XN: pll_nand2_pdk110_15) + Output Inverter (XI: pll_inv_pdk110_48)", halign="middle") => @SET-STYLE $subtitle_style
// }
ends tx_and_pdk110_47
