// RNL cell RISCA_JL/L1_IO_ring
// @RNL(type="header") {
//   @VERSION("0.4");
//   @USE-PACKAGE(name="rnl-std-all", version="0.4");
//   @USE-PACKAGE(name="rnl-std-fill") {};
//   @USE-PACKAGE(name="eda-symbol", version="0.2", path="eda-symbol.rnl");
//   @USE-PACKAGE(name="eda-style", version="0.2", path="eda-style.rnl");
//   @DEVICE(model="rupolym*", terminals=["p", "n"], type="r")
// }
subckt L1_IO_ring CLKN CLKP D0 D0_CORE D1 D1_CORE D2 D2_CORE D3 D3_CORE D4 \
        D4_CORE D5 D5_CORE D6 D6_CORE D7 D7_CORE D8 D8_CORE D9 D9_CORE D10 \
        D10_CORE D11 D11_CORE D12 D12_CORE D13 D13_CORE D14 D14_CORE D15 \
        D15_CORE DCLK DCLK_CORE GAMP GCKB GCKB_CORE GCLK GDIG GIOH GIOL \
        GNDA GNDA_CORE GREC GREF IB IN1N IN1P IN2N IN2P INCM RST RST_CORE \
        SCK SCK_CORE SDI SDI_CORE SDO SDO_CORE SLP SLP_CORE VAMP VANA \
        VANA_CORE VBS VCKB VCKB_CORE VCLK VCM VDIG VIOH VIOL VREC VREF \
        VSAM
    I66 (VANA_CORE VANA GNDA GIOL) PVDD3AC_H_G
    I157 (VCKB_CORE VCKB GCKB GIOL) PVDD3AC_H_G
    I98 (POC VIOL VIOH GIOL GIOH) PVSS2DGZ_H_G
    I85 (POC VIOL VIOH GIOL GIOH) PVSS2DGZ_H_G
    I156 (GCKB_CORE VCKB GCKB GIOL) PVSS3AC_H_G
    I133 (GNDA_CORE VANA GNDA GIOL) PVSS3AC_H_G
    I81 (CLKN VCKB GCKB GIOL) PDB3AC_V_G
    I80 (CLKP VCKB GCKB GIOL) PDB3AC_V_G
    I75 (INCM VANA GNDA GIOL) PDB3AC_V_G
    I74 (IB VANA GNDA GIOL) PDB3AC_V_G
    I146 (VCLK VANA GNDA GIOL) PVDD1AC_H_G
    I144 (VREC VANA GNDA GIOL) PVDD1AC_H_G
    I143 (VAMP VANA GNDA GIOL) PVDD1AC_H_G
    I135 (VSAM VANA GNDA GIOL) PVDD1AC_H_G
    I141 (VBS VANA GNDA GIOL) PVDD1AC_H_G
    I139 (VDIG VANA GNDA GIOL) PVDD1AC_H_G
    I60 (POC VIOL VIOH GIOL GIOH) PVDD2POC_V_G
    I147 (GCLK VANA GNDA GIOL) PVSS1AC_H_G
    I145 (GREC VANA GNDA GIOL) PVSS1AC_H_G
    I142 (GAMP VANA GNDA GIOL) PVSS1AC_H_G
    I138 (GDIG VANA GNDA GIOL) PVSS1AC_H_G
    I155 (GCKB_CORE VCKB GCKB GIOL) PVSS3AC_V_G
    I77 (GNDA_CORE VANA GNDA GIOL) PVSS3AC_V_G
    I76 (GNDA_CORE VANA GNDA GIOL) PVSS3AC_V_G
    I63 (GNDA_CORE VANA GNDA GIOL) PVSS3AC_V_G
    I152 (GNDA_CORE VANA GNDA GIOL) PVSS3AC_V_G
    I73 (GNDA_CORE VANA GNDA GIOL) PVSS3AC_V_G
    I58 (POC VIOL VIOH GIOL GIOH) PVSS2DGZ_V_G
    I56 (POC VIOL VIOH GIOL GIOH) PVSS2DGZ_V_G
    I132 (net21 DCLK_CORE net2 DCLK POC net9 VIOL VIOH GIOL GIOH) \
        PDDW16SDGZ_V_G
    I130 (net19 D14_CORE net2 D14 POC net9 VIOL VIOH GIOL GIOH) \
        PDDW16SDGZ_V_G
    I129 (net20 D15_CORE net2 D15 POC net9 VIOL VIOH GIOL GIOH) \
        PDDW16SDGZ_V_G
    I126 (net17 D12_CORE net2 D12 POC net9 VIOL VIOH GIOL GIOH) \
        PDDW16SDGZ_V_G
    I125 (net18 D13_CORE net2 D13 POC net9 VIOL VIOH GIOL GIOH) \
        PDDW16SDGZ_V_G
    I123 (net15 D10_CORE net2 D10 POC net9 VIOL VIOH GIOL GIOH) \
        PDDW16SDGZ_V_G
    I121 (net16 D11_CORE net2 D11 POC net9 VIOL VIOH GIOL GIOH) \
        PDDW16SDGZ_V_G
    I118 (net10 D8_CORE net2 D8 POC net9 VIOL VIOH GIOL GIOH) \
        PDDW16SDGZ_V_G
    I117 (net14 D9_CORE net2 D9 POC net9 VIOL VIOH GIOL GIOH) \
        PDDW16SDGZ_V_G
    I111 (net11 D6_CORE net2 D6 POC net9 VIOL VIOH GIOL GIOH) \
        PDDW16SDGZ_V_G
    I114 (net8 D7_CORE net2 D7 POC net9 VIOL VIOH GIOL GIOH) \
        PDDW16SDGZ_V_G
    I24 (POC VIOL VIOL GIOL GIOH) PVDD1DGZ_H_G
    I107 (net13 D4_CORE net2 D4 POC net9 VIOL VIOH GIOL GIOH) \
        PDDW16SDGZ_H_G
    I106 (net12 D3_CORE net2 D3 POC net9 VIOL VIOH GIOL GIOH) \
        PDDW16SDGZ_H_G
    I91 (RST_CORE net2 net9 RST POC net9 VIOL VIOH GIOL GIOH) \
        PDDW16SDGZ_H_G
    I103 (net6 D2_CORE net2 D2 POC net9 VIOL VIOH GIOL GIOH) \
        PDDW16SDGZ_H_G
    I102 (net4 D1_CORE net2 D1 POC net9 VIOL VIOH GIOL GIOH) \
        PDDW16SDGZ_H_G
    I87 (SDI_CORE net2 net9 SDI POC net9 VIOL VIOH GIOL GIOH) \
        PDDW16SDGZ_H_G
    I89 (net3 SDO_CORE net2 SDO POC net9 VIOL VIOH GIOL GIOH) \
        PDDW16SDGZ_H_G
    I88 (SCK_CORE net2 net9 SCK POC net9 VIOL VIOH GIOL GIOH) \
        PDDW16SDGZ_H_G
    I86 (SLP_CORE net2 net9 SLP POC net9 VIOL VIOH GIOL GIOH) \
        PDDW16SDGZ_H_G
    I109 (net23 D5_CORE net2 D5 POC net9 VIOL VIOH GIOL GIOH) \
        PDDW16SDGZ_H_G
    I99 (net22 D0_CORE net2 D0 POC net9 VIOL VIOH GIOL GIOH) \
        PDDW16SDGZ_H_G
R1 (GIOL net2 ) rupolym l=1u w=1u m=1 multi=(1)

R0 (VIOL net9 ) rupolym l=1u w=1u m=1 multi=(1)

    I137 (VCM VANA GNDA GIOL) PDB3AC_H_G
    I159 (GREF VANA GNDA GIOL) PDB3AC_H_G
    I160 (VREF VANA GNDA GIOL) PDB3AC_H_G
    I84 (POC VIOL VIOH GIOL GIOH) PVSS1DGZ_H_G
    I153 (POC VIOL VIOH GIOL GIOH) PVSS1DGZ_H_G
    I55 (POC VIOL VIOH GIOL GIOH) PVSS1DGZ_H_G
// @RNL(author="rnl-virtuoso") {
//   %symbol_0 = @DEFINE-SYMBOL(box=[5, 0, 27, 16]) {
//     @RECTANGLE {(5, 2) (27, 14)};
//     @LINE {(6, 14) (6, 16)};
//     @LINE {(12, 14) (12, 16)};
//     @LINE {(15, 14) (15, 16)};
//     @LINE {(21, 14) (21, 16)};
//     @LINE {(16, 0) (16, 2)};
//     ? @TEXT("${model}", size=1, halign="middle", valign="middle", key="model") => @PLACE(16, 7);
//     ? @TEXT("${name}", size=1, halign="middle", valign="middle", key="name") => @PLACE(16, 9);
//     (6, 16) @PIN(terminal=1);
//     (8.6, 13) @TEXT("POC", size=1, halign="end", valign="middle");
//     (16, 0) @PIN(terminal=2);
//     (14.4, 3) @TEXT("VDD", size=1, halign="start", valign="middle");
//     (12, 16) @PIN(terminal=4);
//     (14.6, 13) @TEXT("VSS", size=1, halign="end", valign="middle");
//     (15, 16) @PIN(terminal=3);
//     (20.6, 13) @TEXT("VDDPST", size=1, halign="end", valign="middle");
//     (21, 16) @PIN(terminal=5);
//     (26.6, 13) @TEXT("VSSPST", size=1, halign="end", valign="middle")
//   };
//   #"I24" @SET-SYMBOL %symbol_0;
//   #"I24" @PLACE(448, 113) => @ORIENT("R180");
//   %symbol_1 = @DEFINE-SYMBOL(box=[-5, 0, 27, 16]) {
//     @LINE {(2, 14) (2, 16)};
//     @LINE {(4, 14) (4, 16)};
//     @LINE {(-4, 14) (-4, 16)};
//     @LINE {(-2, 14) (-2, 16)};
//     @LINE {(11, 0) (11, 2)};
//     @RECTANGLE {(-5, 2) (27, 14)};
//     @LINE {(6, 14) (6, 16)};
//     @LINE {(9, 14) (9, 16)};
//     @LINE {(12, 14) (12, 16)};
//     @LINE {(15, 14) (15, 16)};
//     @LINE {(21, 14) (21, 16)};
//     ? @TEXT("${model}", size=1, halign="middle", valign="middle", key="model") => @PLACE(11, 7);
//     ? @TEXT("${name}", size=1, halign="middle", valign="middle", key="name") => @PLACE(11, 9);
//     (2, 16) @PIN(terminal=6);
//     (0.4, 13) @TEXT("REN", size=1, halign="start", valign="middle");
//     (4, 16) @PIN(terminal=1);
//     (4.6, 13) @TEXT("C", size=1, halign="end", valign="middle");
//     (-2, 16) @PIN(terminal=3);
//     (-3.6, 13) @TEXT("OEN", size=1, halign="start", valign="middle");
//     (-4, 16) @PIN(terminal=2);
//     (-4.6, 13) @TEXT("I", size=1, halign="start", valign="middle");
//     (11, 0) @PIN(terminal=4);
//     (12.6, 3) @TEXT("PAD", size=1, halign="end", valign="middle");
//     (6, 16) @PIN(terminal=5);
//     (8.6, 13) @TEXT("POC", size=1, halign="end", valign="middle");
//     (9, 16) @PIN(terminal=7);
//     (11.6, 13) @TEXT("VDD", size=1, halign="end", valign="middle");
//     (12, 16) @PIN(terminal=9);
//     (14.6, 13) @TEXT("VSS", size=1, halign="end", valign="middle");
//     (15, 16) @PIN(terminal=8);
//     (20.6, 13) @TEXT("VDDPST", size=1, halign="end", valign="middle");
//     (21, 16) @PIN(terminal=10);
//     (26.6, 13) @TEXT("VSSPST", size=1, halign="end", valign="middle")
//   };
//   #"I130" @SET-SYMBOL %symbol_1;
//   #"I130" @PLACE(501, -49) => @ORIENT("MYR90");
//   %symbol_2 = @DEFINE-SYMBOL(box=[-12, 0, 5, 14]) {
//     @LINE {(-3, 0) (-3, 2)};
//     @RECTANGLE {(-12, 2) (5, 14)};
//     ? @TEXT("${model}", size=1, halign="middle", valign="middle", key="model") => @PLACE(-3, 7);
//     ? @TEXT("${name}", size=1, halign="middle", valign="middle", key="name") => @PLACE(-3, 9);
//     (-4, 14) @PIN(terminal=3);
//     (-4.6, 13) @TEXT("TACVSS", size=1, halign="start", valign="middle");
//     (2, 14) @PIN(terminal=4);
//     (1.4, 13) @TEXT("VSS", size=1, halign="start", valign="middle");
//     (-3, 0) @PIN(terminal=1);
//     (-4.6, 3) @TEXT("AVDD", size=1, halign="start", valign="middle");
//     (-10, 14) @PIN(terminal=2);
//     (-10.6, 13) @TEXT("TACVDD", size=1, halign="start", valign="middle")
//   };
//   #"I146" @SET-SYMBOL %symbol_2;
//   #"I146" @PLACE(343, 113) => @ORIENT("R180");
//   %symbol_3 = @DEFINE-SYMBOL(box=[-12, 0, 5, 14]) {
//     @LINE {(-3, 0) (-3, 2)};
//     @RECTANGLE {(-12, 2) (5, 14)};
//     ? @TEXT("${model}", size=1, halign="middle", valign="middle", key="model") => @PLACE(-3, 7);
//     ? @TEXT("${name}", size=1, halign="middle", valign="middle", key="name") => @PLACE(-3, 9);
//     (-3, 0) @PIN(terminal=1);
//     (-4.6, 3) @TEXT("AIO", size=1, halign="start", valign="middle");
//     (-4, 14) @PIN(terminal=3);
//     (-4.6, 13) @TEXT("TACVSS", size=1, halign="start", valign="middle");
//     (2, 14) @PIN(terminal=4);
//     (1.4, 13) @TEXT("VSS", size=1, halign="start", valign="middle");
//     (-10, 14) @PIN(terminal=2);
//     (-10.6, 13) @TEXT("TACVDD", size=1, halign="start", valign="middle")
//   };
//   #"I137" @SET-SYMBOL %symbol_3;
//   #"I137" @PLACE(102, 113) => @ORIENT("R180");
//   #"I139" @SET-SYMBOL %symbol_2;
//   #"I139" @PLACE(4, 113) => @ORIENT("R180");
//   #"I144" @SET-SYMBOL %symbol_2;
//   #"I144" @PLACE(244, 113) => @ORIENT("R180");
//   %symbol_4 = @DEFINE-SYMBOL(box=[5, 0, 27, 16]) {
//     @RECTANGLE {(5, 2) (27, 14)};
//     @LINE {(6, 14) (6, 16)};
//     @LINE {(12, 14) (12, 16)};
//     @LINE {(9, 14) (9, 16)};
//     @LINE {(15, 14) (15, 16)};
//     @LINE {(16, 0) (16, 2)};
//     ? @TEXT("${model}", size=1, halign="middle", valign="middle", key="model") => @PLACE(16, 7);
//     ? @TEXT("${name}", size=1, halign="middle", valign="middle", key="name") => @PLACE(16, 9);
//     (6, 16) @PIN(terminal=1);
//     (8.6, 13) @TEXT("POC", size=1, halign="end", valign="middle");
//     (9, 16) @PIN(terminal=2);
//     (11.6, 13) @TEXT("VDD", size=1, halign="end", valign="middle");
//     (12, 16) @PIN(terminal=4);
//     (14.6, 13) @TEXT("VSS", size=1, halign="end", valign="middle");
//     (15, 16) @PIN(terminal=3);
//     (20.6, 13) @TEXT("VDDPST", size=1, halign="end", valign="middle");
//     (16, 0) @PIN(terminal=5);
//     (14.4, 3) @TEXT("VSSPST", size=1, halign="start", valign="middle")
//   };
//   #"I98" @SET-SYMBOL %symbol_4;
//   #"I98" @PLACE(461, -435) => @ORIENT("MY");
//   %symbol_5 = @DEFINE-SYMBOL(box=[-5, 0, 27, 16]) {
//     @LINE {(2, 14) (2, 16)};
//     @LINE {(4, 14) (4, 16)};
//     @LINE {(-4, 14) (-4, 16)};
//     @LINE {(-2, 14) (-2, 16)};
//     @LINE {(11, 0) (11, 2)};
//     @RECTANGLE {(-5, 2) (27, 14)};
//     @LINE {(6, 14) (6, 16)};
//     @LINE {(9, 14) (9, 16)};
//     @LINE {(12, 14) (12, 16)};
//     @LINE {(15, 14) (15, 16)};
//     @LINE {(21, 14) (21, 16)};
//     ? @TEXT("${model}", size=1, halign="middle", valign="middle", key="model") => @PLACE(11, 7);
//     ? @TEXT("${name}", size=1, halign="middle", valign="middle", key="name") => @PLACE(11, 9);
//     (2, 16) @PIN(terminal=6);
//     (0.4, 13) @TEXT("REN", size=1, halign="start", valign="middle");
//     (4, 16) @PIN(terminal=1);
//     (4.6, 13) @TEXT("C", size=1, halign="end", valign="middle");
//     (-2, 16) @PIN(terminal=3);
//     (-3.6, 13) @TEXT("OEN", size=1, halign="start", valign="middle");
//     (-4, 16) @PIN(terminal=2);
//     (-4.6, 13) @TEXT("I", size=1, halign="start", valign="middle");
//     (11, 0) @PIN(terminal=4);
//     (12.6, 3) @TEXT("PAD", size=1, halign="end", valign="middle");
//     (6, 16) @PIN(terminal=5);
//     (8.6, 13) @TEXT("POC", size=1, halign="end", valign="middle");
//     (9, 16) @PIN(terminal=7);
//     (11.6, 13) @TEXT("VDD", size=1, halign="end", valign="middle");
//     (12, 16) @PIN(terminal=9);
//     (14.6, 13) @TEXT("VSS", size=1, halign="end", valign="middle");
//     (15, 16) @PIN(terminal=8);
//     (20.6, 13) @TEXT("VDDPST", size=1, halign="end", valign="middle");
//     (21, 16) @PIN(terminal=10);
//     (26.6, 13) @TEXT("VSSPST", size=1, halign="end", valign="middle")
//   };
//   #"I87" @SET-SYMBOL %symbol_5;
//   #"I87" @PLACE(88, -435) => @ORIENT("MY");
//   %symbol_6 = @DEFINE-SYMBOL(box=[5, 0, 27, 16]) {
//     @RECTANGLE {(5, 2) (27, 14)};
//     @LINE {(6, 14) (6, 16)};
//     @LINE {(9, 14) (9, 16)};
//     @LINE {(15, 14) (15, 16)};
//     @LINE {(21, 14) (21, 16)};
//     @LINE {(16, 0) (16, 2)};
//     ? @TEXT("${model}", size=1, halign="middle", valign="middle", key="model") => @PLACE(16, 7);
//     ? @TEXT("${name}", size=1, halign="middle", valign="middle", key="name") => @PLACE(16, 9);
//     (6, 16) @PIN(terminal=1);
//     (8.6, 13) @TEXT("POC", size=1, halign="end", valign="middle");
//     (9, 16) @PIN(terminal=2);
//     (11.6, 13) @TEXT("VDD", size=1, halign="end", valign="middle");
//     (16, 0) @PIN(terminal=4);
//     (14.4, 3) @TEXT("VSS", size=1, halign="start", valign="middle");
//     (15, 16) @PIN(terminal=3);
//     (20.6, 13) @TEXT("VDDPST", size=1, halign="end", valign="middle");
//     (21, 16) @PIN(terminal=5);
//     (26.6, 13) @TEXT("VSSPST", size=1, halign="end", valign="middle")
//   };
//   #"I153" @SET-SYMBOL %symbol_6;
//   #"I153" @PLACE(-33, -435) => @ORIENT("MY");
//   #"I121" @SET-SYMBOL %symbol_1;
//   #"I121" @PLACE(501, -162) => @ORIENT("MYR90");
//   %symbol_7 = @DEFINE-SYMBOL(box=[5, 0, 27, 16]) {
//     @RECTANGLE {(5, 2) (27, 14)};
//     @LINE {(6, 14) (6, 16)};
//     @LINE {(12, 14) (12, 16)};
//     @LINE {(9, 14) (9, 16)};
//     @LINE {(15, 14) (15, 16)};
//     @LINE {(16, 0) (16, 2)};
//     ? @TEXT("${model}", size=1, halign="middle", valign="middle", key="model") => @PLACE(16, 7);
//     ? @TEXT("${name}", size=1, halign="middle", valign="middle", key="name") => @PLACE(16, 9);
//     (6, 16) @PIN(terminal=1);
//     (8.6, 13) @TEXT("POC", size=1, halign="end", valign="middle");
//     (9, 16) @PIN(terminal=2);
//     (11.6, 13) @TEXT("VDD", size=1, halign="end", valign="middle");
//     (12, 16) @PIN(terminal=4);
//     (14.6, 13) @TEXT("VSS", size=1, halign="end", valign="middle");
//     (15, 16) @PIN(terminal=3);
//     (20.6, 13) @TEXT("VDDPST", size=1, halign="end", valign="middle");
//     (16, 0) @PIN(terminal=5);
//     (14.4, 3) @TEXT("VSSPST", size=1, halign="start", valign="middle")
//   };
//   #"I56" @SET-SYMBOL %symbol_7;
//   #"I56" @PLACE(501, -378) => @ORIENT("MYR90");
//   %symbol_8 = @DEFINE-SYMBOL(box=[5, 0, 27, 16]) {
//     @RECTANGLE {(5, 2) (27, 14)};
//     @LINE {(6, 14) (6, 16)};
//     @LINE {(12, 14) (12, 16)};
//     @LINE {(9, 14) (9, 16)};
//     @LINE {(21, 14) (21, 16)};
//     @LINE {(16, 0) (16, 2)};
//     ? @TEXT("${model}", size=1, halign="middle", valign="middle", key="model") => @PLACE(16, 7);
//     ? @TEXT("${name}", size=1, halign="middle", valign="middle", key="name") => @PLACE(16, 9);
//     (6, 16) @PIN(terminal=1);
//     (8.6, 13) @TEXT("POC", size=1, halign="end", valign="middle");
//     (9, 16) @PIN(terminal=2);
//     (11.6, 13) @TEXT("VDD", size=1, halign="end", valign="middle");
//     (12, 16) @PIN(terminal=4);
//     (14.6, 13) @TEXT("VSS", size=1, halign="end", valign="middle");
//     (16, 0) @PIN(terminal=3);
//     (14.4, 3) @TEXT("VDDPST", size=1, halign="start", valign="middle");
//     (21, 16) @PIN(terminal=5);
//     (26.6, 13) @TEXT("VSSPST", size=1, halign="end", valign="middle")
//   };
//   #"I60" @SET-SYMBOL %symbol_8;
//   #"I60" @PLACE(501, 64) => @ORIENT("MYR90");
//   #"I88" @SET-SYMBOL %symbol_5;
//   #"I88" @PLACE(124, -435) => @ORIENT("MY");
//   %symbol_9 = @DEFINE-SYMBOL(box=[-12, 0, 5, 14]) {
//     @LINE {(-3, 0) (-3, 2)};
//     @RECTANGLE {(-12, 2) (5, 14)};
//     ? @TEXT("${model}", size=1, halign="middle", valign="middle", key="model") => @PLACE(-3, 7);
//     ? @TEXT("${name}", size=1, halign="middle", valign="middle", key="name") => @PLACE(-3, 9);
//     (-3, 0) @PIN(terminal=1);
//     (-4.6, 3) @TEXT("AIO", size=1, halign="start", valign="middle");
//     (-4, 14) @PIN(terminal=3);
//     (-4.6, 13) @TEXT("TACVSS", size=1, halign="start", valign="middle");
//     (2, 14) @PIN(terminal=4);
//     (1.4, 13) @TEXT("VSS", size=1, halign="start", valign="middle");
//     (-10, 14) @PIN(terminal=2);
//     (-10.6, 13) @TEXT("TACVDD", size=1, halign="start", valign="middle")
//   };
//   #"I81" @SET-SYMBOL %symbol_9;
//   #"I81" @PLACE(-185, -380) => @ORIENT("R270");
//   #"I118" @SET-SYMBOL %symbol_1;
//   #"I118" @PLACE(501, -276) => @ORIENT("MYR90");
//   #"I86" @SET-SYMBOL %symbol_5;
//   #"I86" @PLACE(51, -435) => @ORIENT("MY");
//   %symbol_10 = @DEFINE-SYMBOL(box=[-12, 0, 5, 14]) {
//     @LINE {(-3, 0) (-3, 2)};
//     @RECTANGLE {(-12, 2) (5, 14)};
//     ? @TEXT("${model}", size=1, halign="middle", valign="middle", key="model") => @PLACE(-3, 7);
//     ? @TEXT("${name}", size=1, halign="middle", valign="middle", key="name") => @PLACE(-3, 9);
//     (-10, 14) @PIN(terminal=1);
//     (-10.6, 13) @TEXT("AVDD", size=1, halign="start", valign="middle");
//     (-4, 14) @PIN(terminal=3);
//     (-4.6, 13) @TEXT("TACVSS", size=1, halign="start", valign="middle");
//     (2, 14) @PIN(terminal=4);
//     (1.4, 13) @TEXT("VSS", size=1, halign="start", valign="middle");
//     (-3, 0) @PIN(terminal=2);
//     (-4.6, 3) @TEXT("TACVDD", size=1, halign="start", valign="middle")
//   };
//   #"I66" @SET-SYMBOL %symbol_10;
//   #"I66" @PLACE(76, 113) => @ORIENT("MX");
//   #"I58" @SET-SYMBOL %symbol_7;
//   #"I58" @PLACE(501, 91) => @ORIENT("MYR90");
//   #"I125" @SET-SYMBOL %symbol_1;
//   #"I125" @PLACE(501, -87) => @ORIENT("MYR90");
//   #"I135" @SET-SYMBOL %symbol_2;
//   #"I135" @PLACE(-62, 113) => @ORIENT("R180");
//   #"I159" @SET-SYMBOL %symbol_3;
//   #"I159" @PLACE(-121, 113) => @ORIENT("R180");
//   %symbol_11 = @DEFINE-SYMBOL(box=[-12, 0, 5, 14]) {
//     @LINE {(-3, 0) (-3, 2)};
//     @RECTANGLE {(-12, 2) (5, 14)};
//     ? @TEXT("${model}", size=1, halign="middle", valign="middle", key="model") => @PLACE(-3, 7);
//     ? @TEXT("${name}", size=1, halign="middle", valign="middle", key="name") => @PLACE(-3, 9);
//     (-3, 0) @PIN(terminal=3);
//     (-4.6, 3) @TEXT("TACVSS", size=1, halign="start", valign="middle");
//     (2, 14) @PIN(terminal=4);
//     (1.4, 13) @TEXT("VSS", size=1, halign="start", valign="middle");
//     (-10, 14) @PIN(terminal=1);
//     (-10.6, 13) @TEXT("AVSS", size=1, halign="start", valign="middle");
//     (-4, 14) @PIN(terminal=2);
//     (-4.6, 13) @TEXT("TACVDD", size=1, halign="start", valign="middle")
//   };
//   #"I155" @SET-SYMBOL %symbol_11;
//   #"I155" @PLACE(-185, -321) => @ORIENT("R270");
//   #"I89" @SET-SYMBOL %symbol_5;
//   #"I89" @PLACE(160, -435) => @ORIENT("MY");
//   #"I102" @SET-SYMBOL %symbol_5;
//   #"I102" @PLACE(271, -435) => @ORIENT("MY");
//   #"I63" @SET-SYMBOL %symbol_11;
//   #"I63" @PLACE(-185, -239) => @ORIENT("R270");
//   %symbol_12 = @DEFINE-SYMBOL(box=[-12, 0, 5, 14]) {
//     @LINE {(-3, 0) (-3, 2)};
//     @RECTANGLE {(-12, 2) (5, 14)};
//     ? @TEXT("${model}", size=1, halign="middle", valign="middle", key="model") => @PLACE(-3, 7);
//     ? @TEXT("${name}", size=1, halign="middle", valign="middle", key="name") => @PLACE(-3, 9);
//     (-3, 0) @PIN(terminal=1);
//     (-4.6, 3) @TEXT("AVSS", size=1, halign="start", valign="middle");
//     (-4, 14) @PIN(terminal=3);
//     (-4.6, 13) @TEXT("TACVSS", size=1, halign="start", valign="middle");
//     (2, 14) @PIN(terminal=4);
//     (1.4, 13) @TEXT("VSS", size=1, halign="start", valign="middle");
//     (-10, 14) @PIN(terminal=2);
//     (-10.6, 13) @TEXT("TACVDD", size=1, halign="start", valign="middle")
//   };
//   #"I142" @SET-SYMBOL %symbol_12;
//   #"I142" @PLACE(173, 113) => @ORIENT("R180");
//   #"I106" @SET-SYMBOL %symbol_5;
//   #"I106" @PLACE(345, -435) => @ORIENT("MY");
//   #"I85" @SET-SYMBOL %symbol_4;
//   #"I85" @PLACE(24, -435) => @ORIENT("MY");
//   #"I152" @SET-SYMBOL %symbol_11;
//   #"I152" @PLACE(-185, -273) => @ORIENT("R270");
//   #"I84" @SET-SYMBOL %symbol_6;
//   #"I84" @PLACE(-4, -435) => @ORIENT("MY");
//   %symbol_13 = @DEFINE-SYMBOL(box=[-12, 0, 5, 14]) {
//     @LINE {(-3, 0) (-3, 2)};
//     @RECTANGLE {(-12, 2) (5, 14)};
//     ? @TEXT("${model}", size=1, halign="middle", valign="middle", key="model") => @PLACE(-3, 7);
//     ? @TEXT("${name}", size=1, halign="middle", valign="middle", key="name") => @PLACE(-3, 9);
//     (-3, 0) @PIN(terminal=3);
//     (-4.6, 3) @TEXT("TACVSS", size=1, halign="start", valign="middle");
//     (2, 14) @PIN(terminal=4);
//     (1.4, 13) @TEXT("VSS", size=1, halign="start", valign="middle");
//     (-10, 14) @PIN(terminal=1);
//     (-10.6, 13) @TEXT("AVSS", size=1, halign="start", valign="middle");
//     (-4, 14) @PIN(terminal=2);
//     (-4.6, 13) @TEXT("TACVDD", size=1, halign="start", valign="middle")
//   };
//   #"I156" @SET-SYMBOL %symbol_13;
//   #"I156" @PLACE(-126, -435) => @ORIENT("R0");
//   #"I157" @SET-SYMBOL %symbol_10;
//   #"I157" @PLACE(-95, -435) => @ORIENT("R0");
//   #"I91" @SET-SYMBOL %symbol_5;
//   #"I91" @PLACE(197, -435) => @ORIENT("MY");
//   #"I143" @SET-SYMBOL %symbol_2;
//   #"I143" @PLACE(210, 113) => @ORIENT("R180");
//   #"I109" @SET-SYMBOL %symbol_5;
//   #"I109" @PLACE(420, -435) => @ORIENT("MY");
//   #"I123" @SET-SYMBOL %symbol_1;
//   #"I123" @PLACE(501, -200) => @ORIENT("MYR90");
//   #"I114" @SET-SYMBOL %symbol_1;
//   #"I114" @PLACE(501, -313) => @ORIENT("MYR90");
//   #"I117" @SET-SYMBOL %symbol_1;
//   #"I117" @PLACE(501, -238) => @ORIENT("MYR90");
//   #"I132" @SET-SYMBOL %symbol_1;
//   #"I132" @PLACE(501, 27) => @ORIENT("MYR90");
//   #"I75" @SET-SYMBOL %symbol_9;
//   #"I75" @PLACE(-185, -25) => @ORIENT("R270");
//   #"I129" @SET-SYMBOL %symbol_1;
//   #"I129" @PLACE(501, -11) => @ORIENT("MYR90");
//   #"I55" @SET-SYMBOL %symbol_6;
//   #"I55" @PLACE(376, 113) => @ORIENT("MX");
//   #"I76" @SET-SYMBOL %symbol_11;
//   #"I76" @PLACE(-185, -62) => @ORIENT("R270");
//   #"I77" @SET-SYMBOL %symbol_11;
//   #"I77" @PLACE(-185, -151) => @ORIENT("R270");
//   %symbol_14 = @DEFINE-SYMBOL(box=[-2, -6, 2, 0]) {
//     @LINE {(0, -6) (0, -4.8) (-1, -4.5) (1, -3.9) (-1, -3.3) (1, -2.7) (-1, -2.1) (1, -1.5) (0, -1.2) (0, 0)};
//     ? @TEXT("${name}", size=0.8, halign="start", valign="baseline", key="name") => @PLACE(1.4, 0.5);
//     ? @TEXT("${model}", size=0.8, halign="end", valign="baseline", key="model") => @PLACE(-1, 0.3);
//     (0, -6) @PIN(terminal=2);
//     (0, 0) @PIN(terminal=1)
//   };
//   #"R1" @SET-SYMBOL %symbol_14;
//   #"R1" @PLACE(401, 81) => @ORIENT("R90");
//   #"I145" @SET-SYMBOL %symbol_12;
//   #"I145" @PLACE(278, 113) => @ORIENT("R180");
//   #"I80" @SET-SYMBOL %symbol_9;
//   #"I80" @PLACE(-185, -351) => @ORIENT("R270");
//   #"I133" @SET-SYMBOL %symbol_13;
//   #"I133" @PLACE(36, 113) => @ORIENT("R180");
//   #"I74" @SET-SYMBOL %symbol_9;
//   #"I74" @PLACE(-185, 9) => @ORIENT("R270");
//   #"I103" @SET-SYMBOL %symbol_5;
//   #"I103" @PLACE(308, -435) => @ORIENT("MY");
//   #"I138" @SET-SYMBOL %symbol_12;
//   #"I138" @PLACE(-29, 113) => @ORIENT("R180");
//   #"I160" @SET-SYMBOL %symbol_3;
//   #"I160" @PLACE(-93, 113) => @ORIENT("R180");
//   #"I126" @SET-SYMBOL %symbol_1;
//   #"I126" @PLACE(501, -125) => @ORIENT("MYR90");
//   #"I111" @SET-SYMBOL %symbol_1;
//   #"I111" @PLACE(501, -351) => @ORIENT("MYR90");
//   #"I73" @SET-SYMBOL %symbol_11;
//   #"I73" @PLACE(-185, 45) => @ORIENT("R270");
//   #"I99" @SET-SYMBOL %symbol_5;
//   #"I99" @PLACE(234, -435) => @ORIENT("MY");
//   #"I141" @SET-SYMBOL %symbol_2;
//   #"I141" @PLACE(137, 113) => @ORIENT("R180");
//   #"I147" @SET-SYMBOL %symbol_12;
//   #"I147" @PLACE(311, 113) => @ORIENT("R180");
//   #"R0" @SET-SYMBOL %symbol_14;
//   #"R0" @PLACE(424, 79) => @ORIENT("R90");
//   #"I107" @SET-SYMBOL %symbol_5;
//   #"I107" @PLACE(382, -435) => @ORIENT("MY");
//   %marker_1 = (341, -395);
//   $FIGURE @ATTACH %marker_1 => @SET-SYMBOL $NO_CONNECT_SYMBOL => @PLACE(341, -395) => @ORIENT("R180");
//   %marker_3 = (461, -15);
//   $FIGURE @ATTACH %marker_3 => @SET-SYMBOL $NO_CONNECT_SYMBOL => @PLACE(461, -15) => @ORIENT("R270");
//   %marker_8 = (461, -317);
//   $FIGURE @ATTACH %marker_8 => @SET-SYMBOL $NO_CONNECT_SYMBOL => @PLACE(461, -317) => @ORIENT("R270");
//   %marker_18 = (461, -242);
//   $FIGURE @ATTACH %marker_18 => @SET-SYMBOL $NO_CONNECT_SYMBOL => @PLACE(461, -242) => @ORIENT("R270");
//   %marker_22 = (461, -166);
//   $FIGURE @ATTACH %marker_22 => @SET-SYMBOL $NO_CONNECT_SYMBOL => @PLACE(461, -166) => @ORIENT("R270");
//   %marker_28 = (378, -395);
//   $FIGURE @ATTACH %marker_28 => @SET-SYMBOL $NO_CONNECT_SYMBOL => @PLACE(378, -395) => @ORIENT("R180");
//   %marker_31 = (-174, -89);
//   $FIGURE @ATTACH %marker_31 => @SET-SYMBOL $NO_CONNECT_SYMBOL => @PLACE(-174, -89) => @ORIENT("R0");
//   %marker_36 = (461, -280);
//   $FIGURE @ATTACH %marker_36 => @SET-SYMBOL $NO_CONNECT_SYMBOL => @PLACE(461, -280) => @ORIENT("R270");
//   %marker_37 = (461, -91);
//   $FIGURE @ATTACH %marker_37 => @SET-SYMBOL $NO_CONNECT_SYMBOL => @PLACE(461, -91) => @ORIENT("R270");
//   %marker_38 = (461, -129);
//   $FIGURE @ATTACH %marker_38 => @SET-SYMBOL $NO_CONNECT_SYMBOL => @PLACE(461, -129) => @ORIENT("R270");
//   %marker_43 = (-173, -207);
//   $FIGURE @ATTACH %marker_43 => @SET-SYMBOL $NO_CONNECT_SYMBOL => @PLACE(-173, -207) => @ORIENT("R0");
//   %marker_44 = (416, -395);
//   $FIGURE @ATTACH %marker_44 => @SET-SYMBOL $NO_CONNECT_SYMBOL => @PLACE(416, -395) => @ORIENT("R180");
//   %marker_47 = (461, -204);
//   $FIGURE @ATTACH %marker_47 => @SET-SYMBOL $NO_CONNECT_SYMBOL => @PLACE(461, -204) => @ORIENT("R270");
//   %marker_50 = (230, -395);
//   $FIGURE @ATTACH %marker_50 => @SET-SYMBOL $NO_CONNECT_SYMBOL => @PLACE(230, -395) => @ORIENT("R180");
//   %marker_61 = (461, 23);
//   $FIGURE @ATTACH %marker_61 => @SET-SYMBOL $NO_CONNECT_SYMBOL => @PLACE(461, 23) => @ORIENT("R270");
//   %marker_64 = (461, -53);
//   $FIGURE @ATTACH %marker_64 => @SET-SYMBOL $NO_CONNECT_SYMBOL => @PLACE(461, -53) => @ORIENT("R270");
//   %marker_65 = (156, -395);
//   $FIGURE @ATTACH %marker_65 => @SET-SYMBOL $NO_CONNECT_SYMBOL => @PLACE(156, -395) => @ORIENT("R180");
//   %marker_66 = (-173, -179);
//   $FIGURE @ATTACH %marker_66 => @SET-SYMBOL $NO_CONNECT_SYMBOL => @PLACE(-173, -179) => @ORIENT("R0");
//   %marker_67 = (304, -395);
//   $FIGURE @ATTACH %marker_67 => @SET-SYMBOL $NO_CONNECT_SYMBOL => @PLACE(304, -395) => @ORIENT("R180");
//   %marker_69 = (267, -395);
//   $FIGURE @ATTACH %marker_69 => @SET-SYMBOL $NO_CONNECT_SYMBOL => @PLACE(267, -395) => @ORIENT("R180");
//   %marker_74 = (461, -355);
//   $FIGURE @ATTACH %marker_74 => @SET-SYMBOL $NO_CONNECT_SYMBOL => @PLACE(461, -355) => @ORIENT("R270");
//   %marker_78 = (-174, -117);
//   $FIGURE @ATTACH %marker_78 => @SET-SYMBOL $NO_CONNECT_SYMBOL => @PLACE(-174, -117) => @ORIENT("R0");
//   %output_port_symbol = @DEFINE-SYMBOL(box=[0, -1, 2, 1]) {
//       @LINE(fill="linecolor", linestyle="none") {(0, -0.9) (0, 0.9) (1.1, 0.9) (2, 0) (1.1, -0.9) (0, -0.9)};
//       %pin = (0, 0) @PIN(terminal="p", direction="left");
//       ? @TEXT("${p}", key="netname", halign="middle") => @PLACE(1, 1.6)
//     };
//   %port_0 = $IO_PORT @ATTACH &"D6" => @PLACE(512, -362) => @ORIENT("R0");
//   %port_0 @SET-SYMBOL %output_port_symbol;
//   %port_0 @TEXT("D6", key="netname");
//   %port_1 = $IO_PORT @ATTACH &"IN2N" => @PLACE(-150, -89) => @ORIENT("R180");
//   %port_2 = $IO_PORT @ATTACH &"IN2N" => @PLACE(-197, -89) => @ORIENT("R0");
//   %port_3 = $IO_PORT @ATTACH &"IN2P" => @PLACE(-150, -117) => @ORIENT("R180");
//   %port_4 = $IO_PORT @ATTACH &"IN2P" => @PLACE(-197, -117) => @ORIENT("R0");
//   %port_5 = $IO_PORT @ATTACH &"VSAM" => @PLACE(-68, 77) => @ORIENT("R90");
//   %port_6 = $IO_PORT @ATTACH &"VSAM" => @PLACE(-59, 124) => @ORIENT("R270");
//   %port_7 = $IO_PORT @ATTACH &"IB" => @PLACE(-149, 3) => @ORIENT("R180");
//   %port_8 = $IO_PORT @ATTACH &"IB" => @PLACE(-196, 12) => @ORIENT("R0");
//   %port_9 = $IO_PORT @ATTACH &"VAMP" => @PLACE(204, 77) => @ORIENT("R90");
//   %port_10 = $IO_PORT @ATTACH &"VAMP" => @PLACE(213, 124) => @ORIENT("R270");
//   %port_11 = $IO_PORT @ATTACH &"GAMP" => @PLACE(167, 76) => @ORIENT("R270");
//   %port_12 = $IO_PORT @ATTACH &"GAMP" => @PLACE(176, 124) => @ORIENT("R270");
//   %port_13 = $IO_PORT @ATTACH &"VBS" => @PLACE(131, 77) => @ORIENT("R90");
//   %port_14 = $IO_PORT @ATTACH &"VBS" => @PLACE(140, 124) => @ORIENT("R270");
//   %input_port_symbol = @DEFINE-SYMBOL(box=[-2, -1, 0, 1]) {
//       @LINE(fill="linecolor", linestyle="none") {(-2, -0.9) (-2, 0.9) (-0.9, 0.9) (0, 0) (-0.9, -0.9) (-2, -0.9)};
//       %pin = (0, 0) @PIN(terminal="p", direction="right");
//       ? @TEXT("${p}", key="netname", halign="middle") => @PLACE(-1, 1.6)
//     };
//   %port_15 = $IO_PORT @ATTACH &"SCK" => @PLACE(113, -448) => @ORIENT("R270");
//   %port_15 @SET-SYMBOL %input_port_symbol;
//   %port_15 @TEXT("SCK", key="netname");
//   %port_16 = $IO_PORT @ATTACH &"INCM" => @PLACE(-149, -31) => @ORIENT("R180");
//   %port_17 = $IO_PORT @ATTACH &"INCM" => @PLACE(-196, -22) => @ORIENT("R0");
//   %port_18 = $IO_PORT @ATTACH &"SDO_CORE" => @PLACE(164, -394) => @ORIENT("R270");
//   %port_18 @SET-SYMBOL %input_port_symbol;
//   %port_18 @TEXT("SDO\_CORE", key="netname");
//   %port_19 = $IO_PORT @ATTACH &"SCK_CORE" => @PLACE(120, -394) => @ORIENT("R90");
//   %port_19 @SET-SYMBOL %output_port_symbol;
//   %port_19 @TEXT("SCK\_CORE", key="netname");
//   %port_20 = $IO_PORT @ATTACH &"SDI" => @PLACE(77, -448) => @ORIENT("R270");
//   %port_20 @SET-SYMBOL %input_port_symbol;
//   %port_20 @TEXT("SDI", key="netname");
//   %port_21 = $IO_PORT @ATTACH &"SDO" => @PLACE(149, -446) => @ORIENT("R270");
//   %port_21 @SET-SYMBOL %output_port_symbol;
//   %port_21 @TEXT("SDO", key="netname");
//   %port_22 = $IO_PORT @ATTACH &"VIOL" => @PLACE(422, 73) => @ORIENT("R270");
//   %port_23 = $IO_PORT @ATTACH &"VIOL" => @PLACE(432, 124) => @ORIENT("R270");
//   %port_24 = $IO_PORT @ATTACH &"D15_CORE" => @PLACE(458, -7) => @ORIENT("R0");
//   %port_24 @SET-SYMBOL %input_port_symbol;
//   %port_24 @TEXT("D15\_CORE", key="netname");
//   %port_25 = $IO_PORT @ATTACH &"D9" => @PLACE(512, -249) => @ORIENT("R0");
//   %port_25 @SET-SYMBOL %output_port_symbol;
//   %port_25 @TEXT("D9", key="netname");
//   %port_26 = $IO_PORT @ATTACH &"D8" => @PLACE(512, -287) => @ORIENT("R0");
//   %port_26 @SET-SYMBOL %output_port_symbol;
//   %port_26 @TEXT("D8", key="netname");
//   %port_27 = $IO_PORT @ATTACH &"D10" => @PLACE(512, -211) => @ORIENT("R0");
//   %port_27 @SET-SYMBOL %output_port_symbol;
//   %port_27 @TEXT("D10", key="netname");
//   %port_28 = $IO_PORT @ATTACH &"D11" => @PLACE(512, -173) => @ORIENT("R0");
//   %port_28 @SET-SYMBOL %output_port_symbol;
//   %port_28 @TEXT("D11", key="netname");
//   %port_29 = $IO_PORT @ATTACH &"D12" => @PLACE(512, -136) => @ORIENT("R0");
//   %port_29 @SET-SYMBOL %output_port_symbol;
//   %port_29 @TEXT("D12", key="netname");
//   %port_30 = $IO_PORT @ATTACH &"D1" => @PLACE(260, -446) => @ORIENT("R270");
//   %port_30 @SET-SYMBOL %output_port_symbol;
//   %port_30 @TEXT("D1", key="netname");
//   %port_31 = $IO_PORT @ATTACH &"D0" => @PLACE(223, -446) => @ORIENT("R270");
//   %port_31 @SET-SYMBOL %output_port_symbol;
//   %port_31 @TEXT("D0", key="netname");
//   %port_32 = $IO_PORT @ATTACH &"GIOH" => @PLACE(512, 75) => @ORIENT("R180");
//   %port_33 = $IO_PORT @ATTACH &"GIOH" => @PLACE(512, -394) => @ORIENT("R180");
//   %port_34 = $IO_PORT @ATTACH &"GIOH" => @PLACE(445, -446) => @ORIENT("R90");
//   %port_35 = $IO_PORT @ATTACH &"GIOH" => @PLACE(8, -446) => @ORIENT("R90");
//   %port_36 = $IO_PORT @ATTACH &"RST" => @PLACE(186, -448) => @ORIENT("R270");
//   %port_36 @SET-SYMBOL %input_port_symbol;
//   %port_36 @TEXT("RST", key="netname");
//   %port_37 = $IO_PORT @ATTACH &"D2" => @PLACE(297, -446) => @ORIENT("R270");
//   %port_37 @SET-SYMBOL %output_port_symbol;
//   %port_37 @TEXT("D2", key="netname");
//   %port_38 = $IO_PORT @ATTACH &"D3" => @PLACE(334, -446) => @ORIENT("R270");
//   %port_38 @SET-SYMBOL %output_port_symbol;
//   %port_38 @TEXT("D3", key="netname");
//   %port_39 = $IO_PORT @ATTACH &"D13" => @PLACE(512, -98) => @ORIENT("R0");
//   %port_39 @SET-SYMBOL %output_port_symbol;
//   %port_39 @TEXT("D13", key="netname");
//   %port_40 = $IO_PORT @ATTACH &"D14" => @PLACE(512, -60) => @ORIENT("R0");
//   %port_40 @SET-SYMBOL %output_port_symbol;
//   %port_40 @TEXT("D14", key="netname");
//   %port_41 = $IO_PORT @ATTACH &"D15" => @PLACE(512, -22) => @ORIENT("R0");
//   %port_41 @SET-SYMBOL %output_port_symbol;
//   %port_41 @TEXT("D15", key="netname");
//   %port_42 = $IO_PORT @ATTACH &"DCLK_CORE" => @PLACE(458, 31) => @ORIENT("R0");
//   %port_42 @SET-SYMBOL %input_port_symbol;
//   %port_42 @TEXT("DCLK\_CORE", key="netname");
//   %port_43 = $IO_PORT @ATTACH &"D14_CORE" => @PLACE(458, -45) => @ORIENT("R0");
//   %port_43 @SET-SYMBOL %input_port_symbol;
//   %port_43 @TEXT("D14\_CORE", key="netname");
//   %port_44 = $IO_PORT @ATTACH &"VREF" => @PLACE(-99, 77) => @ORIENT("R90");
//   %port_45 = $IO_PORT @ATTACH &"VREF" => @PLACE(-90, 124) => @ORIENT("R270");
//   %port_46 = $IO_PORT @ATTACH &"RST_CORE" => @PLACE(193, -394) => @ORIENT("R90");
//   %port_46 @SET-SYMBOL %output_port_symbol;
//   %port_46 @TEXT("RST\_CORE", key="netname");
//   %port_47 = $IO_PORT @ATTACH &"D7" => @PLACE(512, -324) => @ORIENT("R0");
//   %port_47 @SET-SYMBOL %output_port_symbol;
//   %port_47 @TEXT("D7", key="netname");
//   %port_48 = $IO_PORT @ATTACH &"GDIG" => @PLACE(-35, 76) => @ORIENT("R270");
//   %port_49 = $IO_PORT @ATTACH &"GDIG" => @PLACE(-26, 124) => @ORIENT("R270");
//   %port_50 = $IO_PORT @ATTACH &"VANA" => @PLACE(73, 124) => @ORIENT("MYR90");
//   %port_51 = $IO_PORT @ATTACH &"GIOL" => @PLACE(-49, -446) => @ORIENT("R90");
//   %port_52 = $IO_PORT @ATTACH &"GIOL" => @PLACE(-58, -394) => @ORIENT("R90");
//   %port_53 = $IO_PORT @ATTACH &"GIOL" => @PLACE(395, 73) => @ORIENT("R270");
//   %port_54 = $IO_PORT @ATTACH &"GIOL" => @PLACE(392, 124) => @ORIENT("R270");
//   %port_55 = $IO_PORT @ATTACH &"GIOL" => @PLACE(-29, -394) => @ORIENT("R90");
//   %port_56 = $IO_PORT @ATTACH &"GIOL" => @PLACE(-20, -446) => @ORIENT("R90");
//   %port_57 = $IO_PORT @ATTACH &"VIOH" => @PLACE(512, 48) => @ORIENT("R180");
//   %port_58 = $IO_PORT @ATTACH &"DCLK" => @PLACE(512, 16) => @ORIENT("R0");
//   %port_58 @SET-SYMBOL %output_port_symbol;
//   %port_58 @TEXT("DCLK", key="netname");
//   %port_59 = $IO_PORT @ATTACH &"GNDA" => @PLACE(-196, -270) => @ORIENT("R0");
//   %port_60 = $IO_PORT @ATTACH &"GNDA" => @PLACE(39, 124) => @ORIENT("R270");
//   %port_61 = $IO_PORT @ATTACH &"GNDA" => @PLACE(-196, -148) => @ORIENT("R0");
//   %port_62 = $IO_PORT @ATTACH &"GNDA" => @PLACE(-196, -59) => @ORIENT("R0");
//   %port_63 = $IO_PORT @ATTACH &"GNDA" => @PLACE(-196, 48) => @ORIENT("R0");
//   %port_64 = $IO_PORT @ATTACH &"GNDA" => @PLACE(-196, -236) => @ORIENT("R0");
//   %port_65 = $IO_PORT @ATTACH &"GNDA_CORE" => @PLACE(-148, -263) => @ORIENT("R0");
//   %port_66 = $IO_PORT @ATTACH &"GNDA_CORE" => @PLACE(46, 76) => @ORIENT("R270");
//   %port_67 = $IO_PORT @ATTACH &"GNDA_CORE" => @PLACE(-148, -141) => @ORIENT("R0");
//   %port_68 = $IO_PORT @ATTACH &"GNDA_CORE" => @PLACE(-148, -52) => @ORIENT("R0");
//   %port_69 = $IO_PORT @ATTACH &"GNDA_CORE" => @PLACE(-148, 55) => @ORIENT("R0");
//   %port_70 = $IO_PORT @ATTACH &"GNDA_CORE" => @PLACE(-148, -229) => @ORIENT("R0");
//   %port_71 = $IO_PORT @ATTACH &"VDIG" => @PLACE(-2, 77) => @ORIENT("R90");
//   %port_72 = $IO_PORT @ATTACH &"VDIG" => @PLACE(7, 124) => @ORIENT("R270");
//   %port_73 = $IO_PORT @ATTACH &"VCKB_CORE" => @PLACE(-105, -399) => @ORIENT("R270");
//   %port_74 = $IO_PORT @ATTACH &"GCKB" => @PLACE(-129, -446) => @ORIENT("R90");
//   %port_75 = $IO_PORT @ATTACH &"GCKB" => @PLACE(-196, -318) => @ORIENT("R0");
//   %port_76 = $IO_PORT @ATTACH &"IN1P" => @PLACE(-149, -207) => @ORIENT("R180");
//   %port_77 = $IO_PORT @ATTACH &"IN1P" => @PLACE(-196, -207) => @ORIENT("R0");
//   %port_78 = $IO_PORT @ATTACH &"IN1N" => @PLACE(-149, -179) => @ORIENT("R180");
//   %port_79 = $IO_PORT @ATTACH &"IN1N" => @PLACE(-196, -179) => @ORIENT("R0");
//   %port_80 = $IO_PORT @ATTACH &"CLKP" => @PLACE(-149, -357) => @ORIENT("R180");
//   %port_81 = $IO_PORT @ATTACH &"CLKP" => @PLACE(-196, -348) => @ORIENT("R0");
//   %port_82 = $IO_PORT @ATTACH &"CLKN" => @PLACE(-149, -386) => @ORIENT("R180");
//   %port_83 = $IO_PORT @ATTACH &"CLKN" => @PLACE(-196, -377) => @ORIENT("R0");
//   %port_84 = $IO_PORT @ATTACH &"SDI_CORE" => @PLACE(84, -394) => @ORIENT("R90");
//   %port_84 @SET-SYMBOL %output_port_symbol;
//   %port_84 @TEXT("SDI\_CORE", key="netname");
//   %port_85 = $IO_PORT @ATTACH &"SLP_CORE" => @PLACE(47, -394) => @ORIENT("R90");
//   %port_85 @SET-SYMBOL %output_port_symbol;
//   %port_85 @TEXT("SLP\_CORE", key="netname");
//   %port_86 = $IO_PORT @ATTACH &"D1_CORE" => @PLACE(275, -394) => @ORIENT("R270");
//   %port_86 @SET-SYMBOL %input_port_symbol;
//   %port_86 @TEXT("D1\_CORE", key="netname");
//   %port_87 = $IO_PORT @ATTACH &"D5" => @PLACE(409, -446) => @ORIENT("R270");
//   %port_87 @SET-SYMBOL %output_port_symbol;
//   %port_87 @TEXT("D5", key="netname");
//   %port_88 = $IO_PORT @ATTACH &"D0_CORE" => @PLACE(238, -394) => @ORIENT("R270");
//   %port_88 @SET-SYMBOL %input_port_symbol;
//   %port_88 @TEXT("D0\_CORE", key="netname");
//   %port_89 = $IO_PORT @ATTACH &"D4" => @PLACE(371, -446) => @ORIENT("R270");
//   %port_89 @SET-SYMBOL %output_port_symbol;
//   %port_89 @TEXT("D4", key="netname");
//   %port_90 = $IO_PORT @ATTACH &"D2_CORE" => @PLACE(312, -394) => @ORIENT("R270");
//   %port_90 @SET-SYMBOL %input_port_symbol;
//   %port_90 @TEXT("D2\_CORE", key="netname");
//   %port_91 = $IO_PORT @ATTACH &"D3_CORE" => @PLACE(349, -394) => @ORIENT("R270");
//   %port_91 @SET-SYMBOL %input_port_symbol;
//   %port_91 @TEXT("D3\_CORE", key="netname");
//   %port_92 = $IO_PORT @ATTACH &"D5_CORE" => @PLACE(424, -394) => @ORIENT("R270");
//   %port_92 @SET-SYMBOL %input_port_symbol;
//   %port_92 @TEXT("D5\_CORE", key="netname");
//   %port_93 = $IO_PORT @ATTACH &"D4_CORE" => @PLACE(386, -394) => @ORIENT("R270");
//   %port_93 @SET-SYMBOL %input_port_symbol;
//   %port_93 @TEXT("D4\_CORE", key="netname");
//   %port_94 = $IO_PORT @ATTACH &"D13_CORE" => @PLACE(458, -83) => @ORIENT("R0");
//   %port_94 @SET-SYMBOL %input_port_symbol;
//   %port_94 @TEXT("D13\_CORE", key="netname");
//   %port_95 = $IO_PORT @ATTACH &"D12_CORE" => @PLACE(458, -121) => @ORIENT("R0");
//   %port_95 @SET-SYMBOL %input_port_symbol;
//   %port_95 @TEXT("D12\_CORE", key="netname");
//   %port_96 = $IO_PORT @ATTACH &"D11_CORE" => @PLACE(458, -158) => @ORIENT("R0");
//   %port_96 @SET-SYMBOL %input_port_symbol;
//   %port_96 @TEXT("D11\_CORE", key="netname");
//   %port_97 = $IO_PORT @ATTACH &"D10_CORE" => @PLACE(458, -196) => @ORIENT("R0");
//   %port_97 @SET-SYMBOL %input_port_symbol;
//   %port_97 @TEXT("D10\_CORE", key="netname");
//   %port_98 = $IO_PORT @ATTACH &"D9_CORE" => @PLACE(458, -234) => @ORIENT("R0");
//   %port_98 @SET-SYMBOL %input_port_symbol;
//   %port_98 @TEXT("D9\_CORE", key="netname");
//   %port_99 = $IO_PORT @ATTACH &"D8_CORE" => @PLACE(458, -272) => @ORIENT("R0");
//   %port_99 @SET-SYMBOL %input_port_symbol;
//   %port_99 @TEXT("D8\_CORE", key="netname");
//   %port_100 = $IO_PORT @ATTACH &"D7_CORE" => @PLACE(458, -309) => @ORIENT("R0");
//   %port_100 @SET-SYMBOL %input_port_symbol;
//   %port_100 @TEXT("D7\_CORE", key="netname");
//   %port_101 = $IO_PORT @ATTACH &"D6_CORE" => @PLACE(458, -347) => @ORIENT("R0");
//   %port_101 @SET-SYMBOL %input_port_symbol;
//   %port_101 @TEXT("D6\_CORE", key="netname");
//   %port_102 = $IO_PORT @ATTACH &"GREF" => @PLACE(-127, 76) => @ORIENT("R270");
//   %port_103 = $IO_PORT @ATTACH &"GREF" => @PLACE(-118, 124) => @ORIENT("R270");
//   %port_104 = $IO_PORT @ATTACH &"VCM" => @PLACE(96, 77) => @ORIENT("R90");
//   %port_105 = $IO_PORT @ATTACH &"VCM" => @PLACE(105, 124) => @ORIENT("R270");
//   %port_106 = $IO_PORT @ATTACH &"VREC" => @PLACE(238, 77) => @ORIENT("R90");
//   %port_107 = $IO_PORT @ATTACH &"VREC" => @PLACE(247, 124) => @ORIENT("R270");
//   %port_108 = $IO_PORT @ATTACH &"GREC" => @PLACE(272, 76) => @ORIENT("R270");
//   %port_109 = $IO_PORT @ATTACH &"GREC" => @PLACE(281, 124) => @ORIENT("R270");
//   %port_110 = $IO_PORT @ATTACH &"VCLK" => @PLACE(337, 77) => @ORIENT("R90");
//   %port_111 = $IO_PORT @ATTACH &"VCLK" => @PLACE(346, 124) => @ORIENT("R270");
//   %port_112 = $IO_PORT @ATTACH &"GCLK" => @PLACE(305, 76) => @ORIENT("R270");
//   %port_113 = $IO_PORT @ATTACH &"GCLK" => @PLACE(314, 124) => @ORIENT("R270");
//   %port_114 = $IO_PORT @ATTACH &"GCKB_CORE" => @PLACE(-136, -398) => @ORIENT("R90");
//   %port_115 = $IO_PORT @ATTACH &"GCKB_CORE" => @PLACE(-148, -311) => @ORIENT("R0");
//   %port_116 = $IO_PORT @ATTACH &"VANA_CORE" => @PLACE(66, 77) => @ORIENT("MXR90");
//   %port_117 = $IO_PORT @ATTACH &"VCKB" => @PLACE(-98, -446) => @ORIENT("R90");
//   %port_118 = $IO_PORT @ATTACH &"SLP" => @PLACE(40, -448) => @ORIENT("R270");
//   %port_118 @SET-SYMBOL %input_port_symbol;
//   %port_118 @TEXT("SLP", key="netname");
//   %p0 = (513, -362);
//   %wire_0 = &"D6" @WIRE(mode="straight") {#"I111":4 %port_0::pin %p0};
//   %wire_1 = &"SLP" @WIRE(mode="straight") {%port_118::pin #"I86":4};
//   %p1 = (131, 75);
//   %p2 = (131, 116);
//   %wire_2 = &"VBS" @WIRE(mode="straight") {%p1 %port_13::pin %p2};
//   %p3 = (140, 116);
//   %wire_3 = &"VBS" @WIRE(mode="straight") {#"I141":1 %p3};
//   %wire_4 = &"VBS" @WIRE(mode="straight") {%p2 %p3};
//   %p4 = (140, 125);
//   %wire_5 = &"VBS" @WIRE(mode="straight") {%p3 %port_14::pin %p4};
//   %p5 = (513, -324);
//   %wire_6 = &"D7" @WIRE(mode="straight") {#"I114":4 %port_47::pin %p5};
//   %p6 = (513, -287);
//   %wire_7 = &"D8" @WIRE(mode="straight") {#"I118":4 %port_26::pin %p6};
//   %p7 = (513, -249);
//   %wire_8 = &"D9" @WIRE(mode="straight") {#"I117":4 %port_25::pin %p7};
//   %p8 = (-59, 116);
//   %p9 = (-59, 125);
//   %wire_9 = &"VSAM" @WIRE(mode="straight") {%p8 %port_6::pin %p9};
//   %wire_10 = &"VSAM" @WIRE(mode="straight") {#"I135":1 %p8};
//   %p10 = (-68, 116);
//   %wire_11 = &"VSAM" @WIRE(mode="straight") {%p10 %p8};
//   %p11 = (-68, 75);
//   %wire_12 = &"VSAM" @WIRE(mode="straight") {%p11 %port_5::pin %p10};
//   %p12 = (513, -211);
//   %wire_13 = &"D10" @WIRE(mode="straight") {#"I123":4 %port_27::pin %p12};
//   %p13 = (238, 75);
//   %p14 = (238, 116);
//   %wire_14 = &"VREC" @WIRE(mode="straight") {%p13 %port_106::pin %p14};
//   %p15 = (247, 116);
//   %wire_15 = &"VREC" @WIRE(mode="straight") {%p14 %p15};
//   %p16 = (247, 125);
//   %wire_16 = &"VREC" @WIRE(mode="straight") {%p15 %port_107::pin %p16};
//   %wire_17 = &"VREC" @WIRE(mode="straight") {#"I144":1 %p15};
//   %p17 = (513, -173);
//   %wire_18 = &"D11" @WIRE(mode="straight") {#"I121":4 %port_28::pin %p17};
//   %p18 = (513, -136);
//   %wire_19 = &"D12" @WIRE(mode="straight") {#"I126":4 %port_29::pin %p18};
//   %p19 = (281, 116);
//   %wire_20 = &"GREC" @WIRE(mode="straight") {#"I145":1 %p19};
//   %p20 = (281, 125);
//   %wire_21 = &"GREC" @WIRE(mode="straight") {%p19 %port_109::pin %p20};
//   %p21 = (272, 116);
//   %wire_22 = &"GREC" @WIRE(mode="straight") {%p21 %p19};
//   %p22 = (272, 78);
//   %wire_23 = &"GREC" @WIRE(mode="straight") {%p22 %p21};
//   %p23 = (513, -98);
//   %wire_24 = &"D13" @WIRE(mode="straight") {#"I125":4 %port_39::pin %p23};
//   %p24 = (513, -60);
//   %wire_25 = &"D14" @WIRE(mode="straight") {#"I130":4 %port_40::pin %p24};
//   %p25 = (513, -22);
//   %wire_26 = &"D15" @WIRE(mode="straight") {#"I129":4 %port_41::pin %p25};
//   %p26 = (176, 116);
//   %wire_27 = &"GAMP" @WIRE(mode="straight") {#"I142":1 %p26};
//   %p27 = (167, 116);
//   %wire_28 = &"GAMP" @WIRE(mode="straight") {%p27 %p26};
//   %p28 = (176, 125);
//   %wire_29 = &"GAMP" @WIRE(mode="straight") {%p26 %port_12::pin %p28};
//   %p29 = (167, 78);
//   %wire_30 = &"GAMP" @WIRE(mode="straight") {%p29 %p27};
//   %p30 = (66, 75);
//   %wire_31 = &"VANA_CORE" @WIRE(mode="straight") {#"I66":1 %port_116::pin %p30};
//   %wire_32 = &"net4" @WIRE(mode="straight") {#"I102":1 %marker_69};
//   %p31 = (204, 75);
//   %p32 = (204, 116);
//   %wire_33 = &"VAMP" @WIRE(mode="straight") {%p31 %port_9::pin %p32};
//   %p33 = (213, 116);
//   %p34 = (213, 125);
//   %wire_34 = &"VAMP" @WIRE(mode="straight") {%p33 %port_10::pin %p34};
//   %wire_35 = &"VAMP" @WIRE(mode="straight") {#"I143":1 %p33};
//   %wire_36 = &"VAMP" @WIRE(mode="straight") {%p32 %p33};
//   %p35 = (457, -121);
//   %wire_37 = &"D12_CORE" @WIRE(mode="straight") {%p35 %port_95::pin #"I126":2};
//   %p36 = (457, -83);
//   %wire_38 = &"D13_CORE" @WIRE(mode="straight") {%p36 %port_94::pin #"I125":2};
//   %p37 = (457, 31);
//   %wire_39 = &"DCLK_CORE" @WIRE(mode="straight") {%p37 %port_42::pin #"I132":2};
//   %wire_40 = &"SLP_CORE" @WIRE(mode="straight") {%port_85::pin #"I86":1};
//   %p38 = (457, -234);
//   %wire_41 = &"D9_CORE" @WIRE(mode="straight") {%p38 %port_98::pin #"I117":2};
//   %wire_42 = &"SDI" @WIRE(mode="straight") {#"I87":4 %port_20::pin};
//   %p39 = (-188, -377);
//   %p40 = (-188, -386);
//   %wire_43 = &"CLKN" @WIRE(mode="straight") {%p39 %p40};
//   %wire_44 = &"CLKN" @WIRE(mode="straight") {%p39 #"I81":1};
//   %p41 = (-150, -386);
//   %wire_45 = &"CLKN" @WIRE(mode="straight") {%p40 %p41};
//   %p42 = (-197, -377);
//   %wire_46 = &"CLKN" @WIRE(mode="straight") {%p42 %port_83::pin %p39};
//   %p43 = (-197, -348);
//   %p44 = (-188, -348);
//   %wire_47 = &"CLKP" @WIRE(mode="straight") {%p43 %port_81::pin %p44};
//   %p45 = (-188, -357);
//   %wire_48 = &"CLKP" @WIRE(mode="straight") {%p44 %p45};
//   %wire_49 = &"CLKP" @WIRE(mode="straight") {%p44 #"I80":1};
//   %p46 = (-150, -357);
//   %wire_50 = &"CLKP" @WIRE(mode="straight") {%p45 %p46};
//   %wire_51 = &"SDO_CORE" @WIRE(mode="straight") {%port_18::pin #"I89":2};
//   %wire_52 = &"RST_CORE" @WIRE(mode="straight") {%port_46::pin #"I91":1};
//   %wire_53 = &"SCK" @WIRE(mode="straight") {#"I88":4 %port_15::pin};
//   %wire_54 = &"D0_CORE" @WIRE(mode="straight") {#"I99":2 %port_88::pin};
//   %p47 = (457, -347);
//   %wire_55 = &"D6_CORE" @WIRE(mode="straight") {%p47 %port_101::pin #"I111":2};
//   %wire_56 = &"SDI_CORE" @WIRE(mode="straight") {%port_84::pin #"I87":1};
//   %p48 = (371, -447);
//   %wire_57 = &"D4" @WIRE(mode="straight") {#"I107":4 %port_89::pin %p48};
//   %p49 = (305, 116);
//   %p50 = (314, 116);
//   %wire_58 = &"GCLK" @WIRE(mode="straight") {%p49 %p50};
//   %p51 = (314, 125);
//   %wire_59 = &"GCLK" @WIRE(mode="straight") {%p50 %port_113::pin %p51};
//   %wire_60 = &"GCLK" @WIRE(mode="straight") {#"I147":1 %p50};
//   %p52 = (305, 78);
//   %wire_61 = &"GCLK" @WIRE(mode="straight") {%p52 %p49};
//   %p53 = (457, -309);
//   %wire_62 = &"D7_CORE" @WIRE(mode="straight") {%p53 %port_100::pin #"I114":2};
//   %wire_63 = &"net3" @WIRE(mode="straight") {#"I89":1 %marker_65};
//   %p54 = (457, -272);
//   %wire_64 = &"D8_CORE" @WIRE(mode="straight") {%p54 %port_99::pin #"I118":2};
//   %wire_65 = &"net6" @WIRE(mode="straight") {#"I103":1 %marker_67};
//   %p55 = (409, -447);
//   %wire_66 = &"D5" @WIRE(mode="straight") {#"I109":4 %port_87::pin %p55};
//   %p56 = (-151, -89);
//   %wire_67 = &"IN2N" @WIRE(mode="straight") {%marker_31 %p56};
//   %p57 = (-198, -89);
//   %wire_68 = &"IN2N" @WIRE(mode="straight") {%p57 %port_2::pin %marker_31};
//   %p58 = (-151, -117);
//   %wire_69 = &"IN2P" @WIRE(mode="straight") {%marker_78 %p58};
//   %p59 = (-198, -117);
//   %wire_70 = &"IN2P" @WIRE(mode="straight") {%p59 %port_4::pin %marker_78};
//   %p60 = (346, 116);
//   %wire_71 = &"VCLK" @WIRE(mode="straight") {#"I146":1 %p60};
//   %p61 = (346, 125);
//   %wire_72 = &"VCLK" @WIRE(mode="straight") {%p60 %port_111::pin %p61};
//   %p62 = (337, 116);
//   %wire_73 = &"VCLK" @WIRE(mode="straight") {%p62 %p60};
//   %p63 = (337, 75);
//   %wire_74 = &"VCLK" @WIRE(mode="straight") {%p63 %port_110::pin %p62};
//   %p64 = (-130, -412);
//   %p65 = (-108, -412);
//   %wire_75 = &"VCKB" @WIRE(mode="straight") {%p64 %p65};
//   %p66 = (-162, -370);
//   %p67 = (-162, -341);
//   %wire_76 = &"VCKB" @WIRE(mode="straight") {%p66 %p67};
//   %wire_77 = &"VCKB" @WIRE(mode="straight") {#"I80":2 %p67};
//   %wire_78 = &"VCKB" @WIRE(mode="straight") {#"I81":2 %p66};
//   %p68 = (-162, -317);
//   %wire_79 = &"VCKB" @WIRE(mode="straight") {%p68 #"I155":2};
//   %wire_80 = &"VCKB" @WIRE(mode="straight") {%p67 %p68};
//   %p69 = (-162, -412);
//   %wire_81 = &"VCKB" @WIRE(mode="straight") {%p69 %p64};
//   %p70 = (-108, -438);
//   %wire_82 = &"VCKB" @WIRE(mode="straight") {%p70 %p65};
//   %wire_83 = &"VCKB" @WIRE(mode="straight") {%p64 #"I156":2};
//   %p71 = (-98, -438);
//   %wire_84 = &"VCKB" @WIRE(mode="straight") {%p71 %p70};
//   %wire_85 = &"VCKB" @WIRE(mode="straight") {%p69 %p66};
//   %p72 = (-98, -447);
//   %wire_86 = &"VCKB" @WIRE(mode="straight") {%p72 %port_117::pin %p71};
//   %wire_87 = &"VCKB" @WIRE(mode="straight") {%p71 #"I157":2};
//   %p73 = (334, -447);
//   %wire_88 = &"D3" @WIRE(mode="straight") {#"I106":4 %port_38::pin %p73};
//   %p74 = (223, -447);
//   %wire_89 = &"D0" @WIRE(mode="straight") {#"I99":4 %port_31::pin %p74};
//   %p75 = (457, -196);
//   %wire_90 = &"D10_CORE" @WIRE(mode="straight") {%p75 %port_97::pin #"I123":2};
//   %p76 = (297, -447);
//   %wire_91 = &"D2" @WIRE(mode="straight") {#"I103":4 %port_37::pin %p76};
//   %p77 = (395, 93);
//   %p78 = (404, 93);
//   %wire_92 = &"GIOL" @WIRE(mode="straight") {%p77 %p78};
//   %p79 = (-165, -323);
//   %p80 = (-165, -275);
//   %wire_93 = &"GIOL" @WIRE(mode="straight") {%p79 %p80};
//   %p81 = (309, 93);
//   %wire_94 = &"GIOL" @WIRE(mode="straight") {#"I147":4 %p81};
//   %p82 = (78, 93);
//   %p83 = (100, 93);
//   %wire_95 = &"GIOL" @WIRE(mode="straight") {%p82 %p83};
//   %p84 = (341, 93);
//   %wire_96 = &"GIOL" @WIRE(mode="straight") {#"I146":4 %p84};
//   %p85 = (276, 93);
//   %wire_97 = &"GIOL" @WIRE(mode="straight") {%p85 %p81};
//   %wire_98 = &"GIOL" @WIRE(mode="straight") {#"I145":4 %p85};
//   %p86 = (242, 93);
//   %wire_99 = &"GIOL" @WIRE(mode="straight") {#"I144":4 %p86};
//   %p87 = (481, 15);
//   %p88 = (481, 52);
//   %wire_100 = &"GIOL" @WIRE(mode="straight") {%p87 %p88};
//   %p89 = (481, -23);
//   %wire_101 = &"GIOL" @WIRE(mode="straight") {%p89 %p87};
//   %p90 = (481, -61);
//   %wire_102 = &"GIOL" @WIRE(mode="straight") {%p90 %p89};
//   %p91 = (481, -99);
//   %wire_103 = &"GIOL" @WIRE(mode="straight") {%p91 %p90};
//   %p92 = (481, -137);
//   %wire_104 = &"GIOL" @WIRE(mode="straight") {%p92 %p91};
//   %p93 = (481, -174);
//   %wire_105 = &"GIOL" @WIRE(mode="straight") {%p93 %p92};
//   %p94 = (481, -212);
//   %wire_106 = &"GIOL" @WIRE(mode="straight") {%p94 %p93};
//   %p95 = (481, -250);
//   %wire_107 = &"GIOL" @WIRE(mode="straight") {%p95 %p94};
//   %p96 = (481, -288);
//   %wire_108 = &"GIOL" @WIRE(mode="straight") {%p96 %p95};
//   %p97 = (481, -325);
//   %wire_109 = &"GIOL" @WIRE(mode="straight") {%p97 %p96};
//   %p98 = (481, -363);
//   %wire_110 = &"GIOL" @WIRE(mode="straight") {%p98 %p97};
//   %p99 = (481, -390);
//   %wire_111 = &"GIOL" @WIRE(mode="straight") {%p99 %p98};
//   %p100 = (395, 81);
//   %wire_112 = &"GIOL" @WIRE(mode="straight") {%p100 #"R1":1};
//   %p101 = (436, 93);
//   %p102 = (481, 93);
//   %wire_113 = &"GIOL" @WIRE(mode="straight") {%p101 %p102};
//   %p103 = (449, -415);
//   %wire_114 = &"GIOL" @WIRE(mode="straight") {%p103 #"I98":4};
//   %wire_115 = &"GIOL" @WIRE(mode="straight") {%p78 %p101};
//   %p104 = (370, -415);
//   %p105 = (408, -415);
//   %wire_116 = &"GIOL" @WIRE(mode="straight") {%p104 %p105};
//   %p106 = (-93, -415);
//   %p107 = (-61, -415);
//   %wire_117 = &"GIOL" @WIRE(mode="straight") {%p106 %p107};
//   %wire_118 = &"GIOL" @WIRE(mode="straight") {%p105 #"I109":9};
//   %wire_119 = &"GIOL" @WIRE(mode="straight") {%p105 %p103};
//   %p108 = (296, -415);
//   %p109 = (333, -415);
//   %wire_120 = &"GIOL" @WIRE(mode="straight") {%p108 %p109};
//   %p110 = (222, -415);
//   %p111 = (259, -415);
//   %wire_121 = &"GIOL" @WIRE(mode="straight") {%p110 %p111};
//   %wire_122 = &"GIOL" @WIRE(mode="straight") {%p97 #"I114":9};
//   %wire_123 = &"GIOL" @WIRE(mode="straight") {%p111 %p108};
//   %wire_124 = &"GIOL" @WIRE(mode="straight") {%p108 #"I103":9};
//   %wire_125 = &"GIOL" @WIRE(mode="straight") {%p111 #"I102":9};
//   %p112 = (185, -415);
//   %wire_126 = &"GIOL" @WIRE(mode="straight") {%p112 %p110};
//   %wire_127 = &"GIOL" @WIRE(mode="straight") {%p112 #"I91":9};
//   %wire_128 = &"GIOL" @WIRE(mode="straight") {%p109 #"I106":9};
//   %p113 = (148, -415);
//   %wire_129 = &"GIOL" @WIRE(mode="straight") {%p113 %p112};
//   %wire_130 = &"GIOL" @WIRE(mode="straight") {%p113 #"I89":9};
//   %p114 = (112, -415);
//   %wire_131 = &"GIOL" @WIRE(mode="straight") {%p114 %p113};
//   %p115 = (-32, -415);
//   %p116 = (-32, -438);
//   %wire_132 = &"GIOL" @WIRE(mode="straight") {%p115 %p116};
//   %p117 = (-20, -447);
//   %p118 = (-20, -438);
//   %wire_133 = &"GIOL" @WIRE(mode="straight") {%p117 %port_56::pin %p118};
//   %p119 = (-165, -353);
//   %wire_134 = &"GIOL" @WIRE(mode="straight") {#"I80":4 %p119};
//   %p120 = (-165, -382);
//   %wire_135 = &"GIOL" @WIRE(mode="straight") {%p120 %p119};
//   %wire_136 = &"GIOL" @WIRE(mode="straight") {#"I81":4 %p120};
//   %p121 = (-165, -241);
//   %wire_137 = &"GIOL" @WIRE(mode="straight") {%p80 %p121};
//   %wire_138 = &"GIOL" @WIRE(mode="straight") {%p118 %p116};
//   %wire_139 = &"GIOL" @WIRE(mode="straight") {%p79 #"I155":4};
//   %p122 = (-165, -64);
//   %p123 = (-165, -27);
//   %wire_140 = &"GIOL" @WIRE(mode="straight") {%p122 %p123};
//   %wire_141 = &"GIOL" @WIRE(mode="straight") {%p119 %p79};
//   %p124 = (-165, 93);
//   %p125 = (-123, 93);
//   %wire_142 = &"GIOL" @WIRE(mode="straight") {%p124 %p125};
//   %p126 = (395, 75);
//   %wire_143 = &"GIOL" @WIRE(mode="straight") {%p126 %p100};
//   %wire_144 = &"GIOL" @WIRE(mode="straight") {%p88 #"I60":4};
//   %wire_145 = &"GIOL" @WIRE(mode="straight") {%p80 #"I152":4};
//   %p127 = (-29, -415);
//   %p128 = (12, -415);
//   %wire_146 = &"GIOL" @WIRE(mode="straight") {%p127 %p128};
//   %p129 = (-165, -153);
//   %wire_147 = &"GIOL" @WIRE(mode="straight") {%p129 #"I77":4};
//   %wire_148 = &"GIOL" @WIRE(mode="straight") {%p129 %p122};
//   %p130 = (481, 79);
//   %wire_149 = &"GIOL" @WIRE(mode="straight") {%p88 %p130};
//   %wire_150 = &"GIOL" @WIRE(mode="straight") {#"I157":4 %p106};
//   %p131 = (-165, 7);
//   %p132 = (-165, 43);
//   %wire_151 = &"GIOL" @WIRE(mode="straight") {%p131 %p132};
//   %p133 = (135, 93);
//   %wire_152 = &"GIOL" @WIRE(mode="straight") {%p83 %p133};
//   %wire_153 = &"GIOL" @WIRE(mode="straight") {%p100 %p77};
//   %wire_154 = &"GIOL" @WIRE(mode="straight") {%p102 %p130};
//   %wire_155 = &"GIOL" @WIRE(mode="straight") {%p130 #"I58":4};
//   %p134 = (208, 93);
//   %wire_156 = &"GIOL" @WIRE(mode="straight") {%p134 %p86};
//   %wire_157 = &"GIOL" @WIRE(mode="straight") {%p110 #"I99":9};
//   %p135 = (-58, -415);
//   %p136 = (-58, -396);
//   %wire_158 = &"GIOL" @WIRE(mode="straight") {%p135 %p136};
//   %wire_159 = &"GIOL" @WIRE(mode="straight") {%p81 %p84};
//   %wire_160 = &"GIOL" @WIRE(mode="straight") {%p94 #"I123":9};
//   %wire_161 = &"GIOL" @WIRE(mode="straight") {%p93 #"I121":9};
//   %wire_162 = &"GIOL" @WIRE(mode="straight") {%p123 %p131};
//   %wire_163 = &"GIOL" @WIRE(mode="straight") {%p109 %p104};
//   %wire_164 = &"GIOL" @WIRE(mode="straight") {%p98 #"I111":9};
//   %p137 = (481, -415);
//   %wire_165 = &"GIOL" @WIRE(mode="straight") {%p99 %p137};
//   %p138 = (-64, 93);
//   %wire_166 = &"GIOL" @WIRE(mode="straight") {#"I135":4 %p138};
//   %wire_167 = &"GIOL" @WIRE(mode="straight") {#"I137":4 %p83};
//   %wire_168 = &"GIOL" @WIRE(mode="straight") {%p104 #"I107":9};
//   %p139 = (39, -415);
//   %wire_169 = &"GIOL" @WIRE(mode="straight") {%p128 %p139};
//   %wire_170 = &"GIOL" @WIRE(mode="straight") {%p135 %p115};
//   %p140 = (-165, -415);
//   %p141 = (-124, -415);
//   %wire_171 = &"GIOL" @WIRE(mode="straight") {%p140 %p141};
//   %wire_172 = &"GIOL" @WIRE(mode="straight") {%p92 #"I126":9};
//   %wire_173 = &"GIOL" @WIRE(mode="straight") {#"I66":4 %p82};
//   %wire_174 = &"GIOL" @WIRE(mode="straight") {%p90 #"I130":9};
//   %p142 = (-31, 93);
//   %p143 = (2, 93);
//   %wire_175 = &"GIOL" @WIRE(mode="straight") {%p142 %p143};
//   %wire_176 = &"GIOL" @WIRE(mode="straight") {%p86 %p85};
//   %wire_177 = &"GIOL" @WIRE(mode="straight") {%p103 %p137};
//   %wire_178 = &"GIOL" @WIRE(mode="straight") {#"I24":4 %p101};
//   %p144 = (76, -415);
//   %wire_179 = &"GIOL" @WIRE(mode="straight") {%p139 %p144};
//   %wire_180 = &"GIOL" @WIRE(mode="straight") {%p139 #"I86":9};
//   %wire_181 = &"GIOL" @WIRE(mode="straight") {%p128 #"I85":4};
//   %p145 = (-95, 93);
//   %wire_182 = &"GIOL" @WIRE(mode="straight") {#"I160":4 %p145};
//   %wire_183 = &"GIOL" @WIRE(mode="straight") {%p99 #"I56":4};
//   %p146 = (-49, -447);
//   %p147 = (-49, -438);
//   %wire_184 = &"GIOL" @WIRE(mode="straight") {%p146 %port_51::pin %p147};
//   %wire_185 = &"GIOL" @WIRE(mode="straight") {%p84 %p77};
//   %wire_186 = &"GIOL" @WIRE(mode="straight") {%p118 #"I84":4};
//   %wire_187 = &"GIOL" @WIRE(mode="straight") {#"I139":4 %p143};
//   %p148 = (34, 93);
//   %wire_188 = &"GIOL" @WIRE(mode="straight") {%p148 %p82};
//   %wire_189 = &"GIOL" @WIRE(mode="straight") {%p145 %p138};
//   %wire_190 = &"GIOL" @WIRE(mode="straight") {%p87 #"I132":9};
//   %wire_191 = &"GIOL" @WIRE(mode="straight") {%p96 #"I118":9};
//   %p149 = (392, 125);
//   %p150 = (392, 116);
//   %wire_192 = &"GIOL" @WIRE(mode="straight") {%p149 %port_54::pin %p150};
//   %p151 = (404, 116);
//   %wire_193 = &"GIOL" @WIRE(mode="straight") {%p150 %p151};
//   %wire_194 = &"GIOL" @WIRE(mode="straight") {%p150 #"I55":4};
//   %wire_195 = &"GIOL" @WIRE(mode="straight") {%p141 #"I156":4};
//   %wire_196 = &"GIOL" @WIRE(mode="straight") {%p114 #"I88":9};
//   %wire_197 = &"GIOL" @WIRE(mode="straight") {%p115 %p127};
//   %wire_198 = &"GIOL" @WIRE(mode="straight") {%p122 #"I76":4};
//   %wire_199 = &"GIOL" @WIRE(mode="straight") {%p144 %p114};
//   %wire_200 = &"GIOL" @WIRE(mode="straight") {%p141 %p106};
//   %p152 = (-29, -396);
//   %wire_201 = &"GIOL" @WIRE(mode="straight") {%p127 %p152};
//   %wire_202 = &"GIOL" @WIRE(mode="straight") {%p147 #"I153":4};
//   %wire_203 = &"GIOL" @WIRE(mode="straight") {%p107 %p135};
//   %wire_204 = &"GIOL" @WIRE(mode="straight") {#"I138":4 %p142};
//   %wire_205 = &"GIOL" @WIRE(mode="straight") {%p121 %p129};
//   %wire_206 = &"GIOL" @WIRE(mode="straight") {#"I75":4 %p123};
//   %wire_207 = &"GIOL" @WIRE(mode="straight") {%p95 #"I117":9};
//   %p153 = (-61, -438);
//   %wire_208 = &"GIOL" @WIRE(mode="straight") {%p147 %p153};
//   %wire_209 = &"GIOL" @WIRE(mode="straight") {#"I141":4 %p133};
//   %wire_210 = &"GIOL" @WIRE(mode="straight") {%p138 %p142};
//   %wire_211 = &"GIOL" @WIRE(mode="straight") {%p125 %p145};
//   %p154 = (171, 93);
//   %wire_212 = &"GIOL" @WIRE(mode="straight") {#"I142":4 %p154};
//   %wire_213 = &"GIOL" @WIRE(mode="straight") {%p107 %p153};
//   %wire_214 = &"GIOL" @WIRE(mode="straight") {%p89 #"I129":9};
//   %wire_215 = &"GIOL" @WIRE(mode="straight") {%p91 #"I125":9};
//   %wire_216 = &"GIOL" @WIRE(mode="straight") {%p151 %p78};
//   %wire_217 = &"GIOL" @WIRE(mode="straight") {%p133 %p154};
//   %wire_218 = &"GIOL" @WIRE(mode="straight") {#"I143":4 %p134};
//   %wire_219 = &"GIOL" @WIRE(mode="straight") {#"I74":4 %p131};
//   %wire_220 = &"GIOL" @WIRE(mode="straight") {%p132 #"I73":4};
//   %wire_221 = &"GIOL" @WIRE(mode="straight") {#"I133":4 %p148};
//   %wire_222 = &"GIOL" @WIRE(mode="straight") {%p144 #"I87":9};
//   %wire_223 = &"GIOL" @WIRE(mode="straight") {%p140 %p120};
//   %wire_224 = &"GIOL" @WIRE(mode="straight") {%p132 %p124};
//   %wire_225 = &"GIOL" @WIRE(mode="straight") {%p121 #"I63":4};
//   %wire_226 = &"GIOL" @WIRE(mode="straight") {#"I159":4 %p125};
//   %wire_227 = &"GIOL" @WIRE(mode="straight") {%p143 %p148};
//   %wire_228 = &"GIOL" @WIRE(mode="straight") {%p154 %p134};
//   %wire_229 = &"SCK_CORE" @WIRE(mode="straight") {%port_19::pin #"I88":1};
//   %wire_230 = &"D2_CORE" @WIRE(mode="straight") {#"I103":2 %port_90::pin};
//   %wire_231 = &"D5_CORE" @WIRE(mode="straight") {#"I109":2 %port_92::pin};
//   %p155 = (-150, -179);
//   %wire_232 = &"IN1N" @WIRE(mode="straight") {%marker_66 %p155};
//   %p156 = (-197, -179);
//   %wire_233 = &"IN1N" @WIRE(mode="straight") {%p156 %port_79::pin %marker_66};
//   %p157 = (-150, -207);
//   %wire_234 = &"IN1P" @WIRE(mode="straight") {%marker_43 %p157};
//   %p158 = (-197, -207);
//   %wire_235 = &"IN1P" @WIRE(mode="straight") {%p158 %port_77::pin %marker_43};
//   %p159 = (260, -447);
//   %wire_236 = &"D1" @WIRE(mode="straight") {#"I102":4 %port_30::pin %p159};
//   %p160 = (-26, 116);
//   %wire_237 = &"GDIG" @WIRE(mode="straight") {#"I138":1 %p160};
//   %p161 = (-26, 125);
//   %wire_238 = &"GDIG" @WIRE(mode="straight") {%p160 %port_49::pin %p161};
//   %p162 = (-35, 116);
//   %wire_239 = &"GDIG" @WIRE(mode="straight") {%p162 %p160};
//   %p163 = (-35, 78);
//   %wire_240 = &"GDIG" @WIRE(mode="straight") {%p163 %p162};
//   %p164 = (321, 90);
//   %wire_241 = &"VANA" @WIRE(mode="straight") {#"I147":2 %p164};
//   %p165 = (63, 90);
//   %p166 = (112, 90);
//   %wire_242 = &"VANA" @WIRE(mode="straight") {%p165 %p166};
//   %p167 = (353, 90);
//   %wire_243 = &"VANA" @WIRE(mode="straight") {#"I146":2 %p167};
//   %p168 = (288, 90);
//   %wire_244 = &"VANA" @WIRE(mode="straight") {#"I145":2 %p168};
//   %p169 = (-83, 90);
//   %wire_245 = &"VANA" @WIRE(mode="straight") {#"I160":2 %p169};
//   %p170 = (254, 90);
//   %wire_246 = &"VANA" @WIRE(mode="straight") {%p170 %p168};
//   %p171 = (63, 116);
//   %wire_247 = &"VANA" @WIRE(mode="straight") {%p171 %p165};
//   %p172 = (40, 90);
//   %wire_248 = &"VANA" @WIRE(mode="straight") {#"I133":2 %p172};
//   %p173 = (14, 90);
//   %wire_249 = &"VANA" @WIRE(mode="straight") {%p173 %p172};
//   %p174 = (-162, -58);
//   %p175 = (-162, -15);
//   %wire_250 = &"VANA" @WIRE(mode="straight") {%p174 %p175};
//   %p176 = (-162, 19);
//   %wire_251 = &"VANA" @WIRE(mode="straight") {#"I74":2 %p176};
//   %p177 = (-162, 90);
//   %p178 = (-111, 90);
//   %wire_252 = &"VANA" @WIRE(mode="straight") {%p177 %p178};
//   %wire_253 = &"VANA" @WIRE(mode="straight") {#"I137":2 %p166};
//   %wire_254 = &"VANA" @WIRE(mode="straight") {%p172 %p165};
//   %p179 = (147, 90);
//   %p180 = (183, 90);
//   %wire_255 = &"VANA" @WIRE(mode="straight") {%p179 %p180};
//   %wire_256 = &"VANA" @WIRE(mode="straight") {%p174 #"I76":2};
//   %p181 = (-52, 90);
//   %p182 = (-19, 90);
//   %wire_257 = &"VANA" @WIRE(mode="straight") {%p181 %p182};
//   %wire_258 = &"VANA" @WIRE(mode="straight") {#"I144":2 %p170};
//   %wire_259 = &"VANA" @WIRE(mode="straight") {%p169 %p181};
//   %p183 = (220, 90);
//   %wire_260 = &"VANA" @WIRE(mode="straight") {%p180 %p183};
//   %wire_261 = &"VANA" @WIRE(mode="straight") {%p183 %p170};
//   %wire_262 = &"VANA" @WIRE(mode="straight") {#"I139":2 %p173};
//   %wire_263 = &"VANA" @WIRE(mode="straight") {#"I138":2 %p182};
//   %wire_264 = &"VANA" @WIRE(mode="straight") {%p168 %p164};
//   %p184 = (-162, -269);
//   %p185 = (-162, -235);
//   %wire_265 = &"VANA" @WIRE(mode="straight") {%p184 %p185};
//   %p186 = (-162, -147);
//   %wire_266 = &"VANA" @WIRE(mode="straight") {%p186 %p174};
//   %p187 = (73, 116);
//   %wire_267 = &"VANA" @WIRE(mode="straight") {%p187 %p171};
//   %wire_268 = &"VANA" @WIRE(mode="straight") {#"I135":2 %p181};
//   %p188 = (-162, 49);
//   %wire_269 = &"VANA" @WIRE(mode="straight") {%p176 %p188};
//   %wire_270 = &"VANA" @WIRE(mode="straight") {#"I142":2 %p180};
//   %wire_271 = &"VANA" @WIRE(mode="straight") {#"I75":2 %p175};
//   %wire_272 = &"VANA" @WIRE(mode="straight") {%p186 #"I77":2};
//   %wire_273 = &"VANA" @WIRE(mode="straight") {%p185 %p186};
//   %wire_274 = &"VANA" @WIRE(mode="straight") {%p166 %p179};
//   %wire_275 = &"VANA" @WIRE(mode="straight") {%p178 %p169};
//   %p189 = (73, 125);
//   %wire_276 = &"VANA" @WIRE(mode="straight") {%p189 %port_50::pin %p187};
//   %wire_277 = &"VANA" @WIRE(mode="straight") {%p185 #"I63":2};
//   %wire_278 = &"VANA" @WIRE(mode="straight") {%p188 #"I73":2};
//   %wire_279 = &"VANA" @WIRE(mode="straight") {%p188 %p177};
//   %wire_280 = &"VANA" @WIRE(mode="straight") {%p182 %p173};
//   %wire_281 = &"VANA" @WIRE(mode="straight") {%p175 %p176};
//   %wire_282 = &"VANA" @WIRE(mode="straight") {%p187 #"I66":2};
//   %wire_283 = &"VANA" @WIRE(mode="straight") {%p184 #"I152":2};
//   %wire_284 = &"VANA" @WIRE(mode="straight") {#"I141":2 %p179};
//   %wire_285 = &"VANA" @WIRE(mode="straight") {#"I143":2 %p183};
//   %wire_286 = &"VANA" @WIRE(mode="straight") {#"I159":2 %p178};
//   %wire_287 = &"VANA" @WIRE(mode="straight") {%p164 %p167};
//   %p190 = (470, -9);
//   %p191 = (470, 29);
//   %wire_288 = &"net2" @WIRE(mode="straight") {%p190 %p191};
//   %p192 = (470, -85);
//   %p193 = (470, -47);
//   %wire_289 = &"net2" @WIRE(mode="straight") {%p192 %p193};
//   %p194 = (470, -160);
//   %p195 = (470, -123);
//   %wire_290 = &"net2" @WIRE(mode="straight") {%p194 %p195};
//   %p196 = (470, -236);
//   %p197 = (470, -198);
//   %wire_291 = &"net2" @WIRE(mode="straight") {%p196 %p197};
//   %p198 = (470, -311);
//   %p199 = (470, -274);
//   %wire_292 = &"net2" @WIRE(mode="straight") {%p198 %p199};
//   %p200 = (384, -404);
//   %p201 = (422, -404);
//   %wire_293 = &"net2" @WIRE(mode="straight") {%p200 %p201};
//   %p202 = (470, -404);
//   %p203 = (470, -349);
//   %wire_294 = &"net2" @WIRE(mode="straight") {%p202 %p203};
//   %wire_295 = &"net2" @WIRE(mode="straight") {%p201 %p202};
//   %p204 = (236, -404);
//   %wire_296 = &"net2" @WIRE(mode="straight") {#"I99":3 %p204};
//   %wire_297 = &"net2" @WIRE(mode="straight") {#"I109":3 %p201};
//   %p205 = (310, -404);
//   %p206 = (347, -404);
//   %wire_298 = &"net2" @WIRE(mode="straight") {%p205 %p206};
//   %wire_299 = &"net2" @WIRE(mode="straight") {#"I103":3 %p205};
//   %wire_300 = &"net2" @WIRE(mode="straight") {%p206 %p200};
//   %p207 = (273, -404);
//   %wire_301 = &"net2" @WIRE(mode="straight") {%p204 %p207};
//   %wire_302 = &"net2" @WIRE(mode="straight") {%p207 %p205};
//   %p208 = (201, -404);
//   %wire_303 = &"net2" @WIRE(mode="straight") {#"I91":2 %p208};
//   %wire_304 = &"net2" @WIRE(mode="straight") {%p208 %p204};
//   %wire_305 = &"net2" @WIRE(mode="straight") {#"I107":3 %p200};
//   %p209 = (128, -404);
//   %p210 = (162, -404);
//   %wire_306 = &"net2" @WIRE(mode="straight") {%p209 %p210};
//   %p211 = (92, -404);
//   %wire_307 = &"net2" @WIRE(mode="straight") {%p211 %p209};
//   %p212 = (55, -404);
//   %wire_308 = &"net2" @WIRE(mode="straight") {%p212 %p211};
//   %wire_309 = &"net2" @WIRE(mode="straight") {#"I89":3 %p210};
//   %wire_310 = &"net2" @WIRE(mode="straight") {%p210 %p208};
//   %wire_311 = &"net2" @WIRE(mode="straight") {%p199 #"I118":3};
//   %wire_312 = &"net2" @WIRE(mode="straight") {%p203 #"I111":3};
//   %wire_313 = &"net2" @WIRE(mode="straight") {%p198 #"I114":3};
//   %wire_314 = &"net2" @WIRE(mode="straight") {%p203 %p198};
//   %wire_315 = &"net2" @WIRE(mode="straight") {#"I88":2 %p209};
//   %wire_316 = &"net2" @WIRE(mode="straight") {#"I102":3 %p207};
//   %p213 = (470, 81);
//   %wire_317 = &"net2" @WIRE(mode="straight") {#"R1":2 %p213};
//   %wire_318 = &"net2" @WIRE(mode="straight") {%p195 %p192};
//   %wire_319 = &"net2" @WIRE(mode="straight") {%p195 #"I126":3};
//   %wire_320 = &"net2" @WIRE(mode="straight") {%p197 #"I123":3};
//   %wire_321 = &"net2" @WIRE(mode="straight") {%p194 #"I121":3};
//   %wire_322 = &"net2" @WIRE(mode="straight") {%p192 #"I125":3};
//   %wire_323 = &"net2" @WIRE(mode="straight") {%p197 %p194};
//   %wire_324 = &"net2" @WIRE(mode="straight") {%p199 %p196};
//   %wire_325 = &"net2" @WIRE(mode="straight") {%p193 #"I130":3};
//   %wire_326 = &"net2" @WIRE(mode="straight") {%p191 #"I132":3};
//   %wire_327 = &"net2" @WIRE(mode="straight") {%p191 %p213};
//   %wire_328 = &"net2" @WIRE(mode="straight") {#"I86":2 %p212};
//   %wire_329 = &"net2" @WIRE(mode="straight") {%p193 %p190};
//   %wire_330 = &"net2" @WIRE(mode="straight") {#"I106":3 %p206};
//   %wire_331 = &"net2" @WIRE(mode="straight") {#"I87":2 %p211};
//   %wire_332 = &"net2" @WIRE(mode="straight") {%p196 #"I117":3};
//   %wire_333 = &"net2" @WIRE(mode="straight") {%p190 #"I129":3};
//   %wire_334 = &"D4_CORE" @WIRE(mode="straight") {#"I107":2 %port_93::pin};
//   %wire_335 = &"RST" @WIRE(mode="straight") {#"I91":4 %port_36::pin};
//   %p214 = (149, -447);
//   %wire_336 = &"SDO" @WIRE(mode="straight") {#"I89":4 %port_21::pin %p214};
//   %p215 = (-105, -397);
//   %wire_337 = &"VCKB_CORE" @WIRE(mode="straight") {#"I157":1 %port_73::pin %p215};
//   %p216 = (-90, 125);
//   %p217 = (-90, 116);
//   %wire_338 = &"VREF" @WIRE(mode="straight") {%p216 %port_45::pin %p217};
//   %wire_339 = &"VREF" @WIRE(mode="straight") {%p217 #"I160":1};
//   %p218 = (-99, 116);
//   %wire_340 = &"VREF" @WIRE(mode="straight") {%p217 %p218};
//   %p219 = (-99, 78);
//   %wire_341 = &"VREF" @WIRE(mode="straight") {%p218 %p219};
//   %p220 = (457, -158);
//   %wire_342 = &"D11_CORE" @WIRE(mode="straight") {%p220 %port_96::pin #"I121":2};
//   %p221 = (-188, 3);
//   %p222 = (-150, 3);
//   %wire_343 = &"IB" @WIRE(mode="straight") {%p221 %p222};
//   %p223 = (-188, 12);
//   %wire_344 = &"IB" @WIRE(mode="straight") {%p223 #"I74":1};
//   %wire_345 = &"IB" @WIRE(mode="straight") {%p223 %p221};
//   %p224 = (-197, 12);
//   %wire_346 = &"IB" @WIRE(mode="straight") {%p224 %port_8::pin %p223};
//   %p225 = (478, 12);
//   %p226 = (478, 36);
//   %wire_347 = &"VIOH" @WIRE(mode="straight") {%p225 %p226};
//   %p227 = (478, -26);
//   %wire_348 = &"VIOH" @WIRE(mode="straight") {%p227 %p225};
//   %p228 = (478, -64);
//   %wire_349 = &"VIOH" @WIRE(mode="straight") {%p228 %p227};
//   %p229 = (478, -102);
//   %wire_350 = &"VIOH" @WIRE(mode="straight") {%p229 %p228};
//   %p230 = (478, -140);
//   %wire_351 = &"VIOH" @WIRE(mode="straight") {%p230 %p229};
//   %p231 = (478, -177);
//   %wire_352 = &"VIOH" @WIRE(mode="straight") {%p231 %p230};
//   %p232 = (478, -215);
//   %wire_353 = &"VIOH" @WIRE(mode="straight") {%p232 %p231};
//   %p233 = (478, -253);
//   %wire_354 = &"VIOH" @WIRE(mode="straight") {%p233 %p232};
//   %p234 = (478, -291);
//   %wire_355 = &"VIOH" @WIRE(mode="straight") {%p234 %p233};
//   %p235 = (478, -328);
//   %wire_356 = &"VIOH" @WIRE(mode="straight") {%p235 %p234};
//   %p236 = (478, -366);
//   %wire_357 = &"VIOH" @WIRE(mode="straight") {%p236 %p235};
//   %p237 = (478, -393);
//   %wire_358 = &"VIOH" @WIRE(mode="straight") {%p237 %p236};
//   %p238 = (446, -412);
//   %wire_359 = &"VIOH" @WIRE(mode="straight") {#"I98":3 %p238};
//   %wire_360 = &"VIOH" @WIRE(mode="straight") {%p228 #"I130":8};
//   %p239 = (367, -412);
//   %p240 = (405, -412);
//   %wire_361 = &"VIOH" @WIRE(mode="straight") {%p239 %p240};
//   %wire_362 = &"VIOH" @WIRE(mode="straight") {%p240 %p238};
//   %wire_363 = &"VIOH" @WIRE(mode="straight") {%p240 #"I109":8};
//   %p241 = (256, -412);
//   %p242 = (293, -412);
//   %wire_364 = &"VIOH" @WIRE(mode="straight") {%p241 %p242};
//   %wire_365 = &"VIOH" @WIRE(mode="straight") {%p242 #"I103":8};
//   %p243 = (330, -412);
//   %wire_366 = &"VIOH" @WIRE(mode="straight") {%p243 #"I106":8};
//   %wire_367 = &"VIOH" @WIRE(mode="straight") {%p241 #"I102":8};
//   %p244 = (182, -412);
//   %p245 = (219, -412);
//   %wire_368 = &"VIOH" @WIRE(mode="straight") {%p244 %p245};
//   %wire_369 = &"VIOH" @WIRE(mode="straight") {%p244 #"I91":8};
//   %p246 = (145, -412);
//   %wire_370 = &"VIOH" @WIRE(mode="straight") {%p246 %p244};
//   %wire_371 = &"VIOH" @WIRE(mode="straight") {%p246 #"I89":8};
//   %p247 = (109, -412);
//   %wire_372 = &"VIOH" @WIRE(mode="straight") {%p247 %p246};
//   %p248 = (478, 76);
//   %wire_373 = &"VIOH" @WIRE(mode="straight") {%p226 %p248};
//   %p249 = (504, 36);
//   %wire_374 = &"VIOH" @WIRE(mode="straight") {%p226 %p249};
//   %p250 = (504, 48);
//   %wire_375 = &"VIOH" @WIRE(mode="straight") {%p250 %p249};
//   %p251 = (513, 48);
//   %wire_376 = &"VIOH" @WIRE(mode="straight") {%p250 %port_57::pin %p251};
//   %p252 = (478, -412);
//   %wire_377 = &"VIOH" @WIRE(mode="straight") {%p237 %p252};
//   %wire_378 = &"VIOH" @WIRE(mode="straight") {#"I60":3 %p250};
//   %p253 = (73, -412);
//   %wire_379 = &"VIOH" @WIRE(mode="straight") {%p253 #"I87":8};
//   %wire_380 = &"VIOH" @WIRE(mode="straight") {#"I58":3 %p248};
//   %wire_381 = &"VIOH" @WIRE(mode="straight") {%p243 %p239};
//   %p254 = (9, -412);
//   %p255 = (36, -412);
//   %wire_382 = &"VIOH" @WIRE(mode="straight") {%p254 %p255};
//   %wire_383 = &"VIOH" @WIRE(mode="straight") {%p253 %p247};
//   %p256 = (-48, -412);
//   %p257 = (-19, -412);
//   %wire_384 = &"VIOH" @WIRE(mode="straight") {%p256 %p257};
//   %wire_385 = &"VIOH" @WIRE(mode="straight") {%p255 %p253};
//   %wire_386 = &"VIOH" @WIRE(mode="straight") {%p232 #"I123":8};
//   %wire_387 = &"VIOH" @WIRE(mode="straight") {%p231 #"I121":8};
//   %wire_388 = &"VIOH" @WIRE(mode="straight") {%p235 #"I114":8};
//   %wire_389 = &"VIOH" @WIRE(mode="straight") {%p227 #"I129":8};
//   %wire_390 = &"VIOH" @WIRE(mode="straight") {%p236 #"I111":8};
//   %wire_391 = &"VIOH" @WIRE(mode="straight") {%p245 #"I99":8};
//   %wire_392 = &"VIOH" @WIRE(mode="straight") {%p242 %p243};
//   %wire_393 = &"VIOH" @WIRE(mode="straight") {%p239 #"I107":8};
//   %p258 = (478, 90);
//   %wire_394 = &"VIOH" @WIRE(mode="straight") {%p258 %p248};
//   %wire_395 = &"VIOH" @WIRE(mode="straight") {%p230 #"I126":8};
//   %wire_396 = &"VIOH" @WIRE(mode="straight") {%p225 #"I132":8};
//   %wire_397 = &"VIOH" @WIRE(mode="straight") {#"I84":3 %p257};
//   %wire_398 = &"VIOH" @WIRE(mode="straight") {%p255 #"I86":8};
//   %wire_399 = &"VIOH" @WIRE(mode="straight") {#"I85":3 %p254};
//   %wire_400 = &"VIOH" @WIRE(mode="straight") {%p238 %p252};
//   %wire_401 = &"VIOH" @WIRE(mode="straight") {%p245 %p241};
//   %wire_402 = &"VIOH" @WIRE(mode="straight") {#"I56":3 %p237};
//   %p259 = (391, 90);
//   %wire_403 = &"VIOH" @WIRE(mode="straight") {#"I55":3 %p259};
//   %wire_404 = &"VIOH" @WIRE(mode="straight") {%p247 #"I88":8};
//   %wire_405 = &"VIOH" @WIRE(mode="straight") {%p257 %p254};
//   %wire_406 = &"VIOH" @WIRE(mode="straight") {%p234 #"I118":8};
//   %wire_407 = &"VIOH" @WIRE(mode="straight") {%p259 %p258};
//   %wire_408 = &"VIOH" @WIRE(mode="straight") {%p233 #"I117":8};
//   %wire_409 = &"VIOH" @WIRE(mode="straight") {#"I153":3 %p256};
//   %wire_410 = &"VIOH" @WIRE(mode="straight") {%p229 #"I125":8};
//   %p260 = (-120, -409);
//   %p261 = (-120, -438);
//   %wire_411 = &"GCKB" @WIRE(mode="straight") {%p260 %p261};
//   %p262 = (-159, -376);
//   %p263 = (-159, -347);
//   %wire_412 = &"GCKB" @WIRE(mode="straight") {%p262 %p263};
//   %wire_413 = &"GCKB" @WIRE(mode="straight") {#"I80":3 %p263};
//   %wire_414 = &"GCKB" @WIRE(mode="straight") {#"I81":3 %p262};
//   %p264 = (-188, -318);
//   %wire_415 = &"GCKB" @WIRE(mode="straight") {%p264 #"I155":3};
//   %p265 = (-159, -327);
//   %p266 = (-188, -327);
//   %wire_416 = &"GCKB" @WIRE(mode="straight") {%p265 %p266};
//   %p267 = (-129, -447);
//   %p268 = (-129, -438);
//   %wire_417 = &"GCKB" @WIRE(mode="straight") {%p267 %port_74::pin %p268};
//   %wire_418 = &"GCKB" @WIRE(mode="straight") {%p261 %p268};
//   %wire_419 = &"GCKB" @WIRE(mode="straight") {%p268 #"I156":3};
//   %p269 = (-159, -409);
//   %wire_420 = &"GCKB" @WIRE(mode="straight") {%p269 %p262};
//   %p270 = (-99, -409);
//   %wire_421 = &"GCKB" @WIRE(mode="straight") {#"I157":3 %p270};
//   %p271 = (-197, -318);
//   %wire_422 = &"GCKB" @WIRE(mode="straight") {%p271 %port_75::pin %p264};
//   %wire_423 = &"GCKB" @WIRE(mode="straight") {%p263 %p265};
//   %wire_424 = &"GCKB" @WIRE(mode="straight") {%p269 %p260};
//   %wire_425 = &"GCKB" @WIRE(mode="straight") {%p266 %p264};
//   %wire_426 = &"GCKB" @WIRE(mode="straight") {%p260 %p270};
//   %p272 = (483, -17);
//   %p273 = (483, 21);
//   %wire_427 = &"POC" @WIRE(mode="straight") {%p272 %p273};
//   %p274 = (483, -55);
//   %wire_428 = &"POC" @WIRE(mode="straight") {%p274 %p272};
//   %p275 = (483, -93);
//   %wire_429 = &"POC" @WIRE(mode="straight") {%p275 %p274};
//   %p276 = (483, -131);
//   %wire_430 = &"POC" @WIRE(mode="straight") {%p276 %p275};
//   %p277 = (483, -168);
//   %wire_431 = &"POC" @WIRE(mode="straight") {%p277 %p276};
//   %p278 = (483, -206);
//   %wire_432 = &"POC" @WIRE(mode="straight") {%p278 %p277};
//   %p279 = (483, -244);
//   %wire_433 = &"POC" @WIRE(mode="straight") {%p279 %p278};
//   %p280 = (483, -282);
//   %wire_434 = &"POC" @WIRE(mode="straight") {%p280 %p279};
//   %p281 = (483, -319);
//   %wire_435 = &"POC" @WIRE(mode="straight") {%p281 %p280};
//   %p282 = (483, -357);
//   %wire_436 = &"POC" @WIRE(mode="straight") {%p282 %p281};
//   %p283 = (483, -384);
//   %wire_437 = &"POC" @WIRE(mode="straight") {%p283 %p282};
//   %p284 = (455, -417);
//   %wire_438 = &"POC" @WIRE(mode="straight") {%p284 #"I98":1};
//   %p285 = (376, -417);
//   %p286 = (414, -417);
//   %wire_439 = &"POC" @WIRE(mode="straight") {%p285 %p286};
//   %p287 = (228, -417);
//   %wire_440 = &"POC" @WIRE(mode="straight") {%p287 #"I99":5};
//   %wire_441 = &"POC" @WIRE(mode="straight") {%p286 #"I109":5};
//   %p288 = (302, -417);
//   %p289 = (339, -417);
//   %wire_442 = &"POC" @WIRE(mode="straight") {%p288 %p289};
//   %p290 = (265, -417);
//   %wire_443 = &"POC" @WIRE(mode="straight") {%p290 %p288};
//   %wire_444 = &"POC" @WIRE(mode="straight") {%p286 %p284};
//   %wire_445 = &"POC" @WIRE(mode="straight") {%p289 %p285};
//   %wire_446 = &"POC" @WIRE(mode="straight") {%p287 %p290};
//   %wire_447 = &"POC" @WIRE(mode="straight") {%p290 #"I102":5};
//   %wire_448 = &"POC" @WIRE(mode="straight") {%p288 #"I103":5};
//   %p291 = (191, -417);
//   %wire_449 = &"POC" @WIRE(mode="straight") {%p291 %p287};
//   %wire_450 = &"POC" @WIRE(mode="straight") {%p291 #"I91":5};
//   %p292 = (154, -417);
//   %wire_451 = &"POC" @WIRE(mode="straight") {%p292 #"I89":5};
//   %p293 = (442, 95);
//   %p294 = (483, 95);
//   %wire_452 = &"POC" @WIRE(mode="straight") {%p293 %p294};
//   %wire_453 = &"POC" @WIRE(mode="straight") {%p275 #"I125":5};
//   %wire_454 = &"POC" @WIRE(mode="straight") {%p283 #"I56":1};
//   %p295 = (483, 85);
//   %wire_455 = &"POC" @WIRE(mode="straight") {%p295 #"I58":1};
//   %p296 = (82, -417);
//   %p297 = (118, -417);
//   %wire_456 = &"POC" @WIRE(mode="straight") {%p296 %p297};
//   %wire_457 = &"POC" @WIRE(mode="straight") {%p297 %p292};
//   %wire_458 = &"POC" @WIRE(mode="straight") {%p292 %p291};
//   %p298 = (45, -417);
//   %wire_459 = &"POC" @WIRE(mode="straight") {%p298 #"I86":5};
//   %wire_460 = &"POC" @WIRE(mode="straight") {%p289 #"I106":5};
//   %p299 = (-10, -417);
//   %wire_461 = &"POC" @WIRE(mode="straight") {%p299 #"I84":1};
//   %wire_462 = &"POC" @WIRE(mode="straight") {%p278 #"I123":5};
//   %wire_463 = &"POC" @WIRE(mode="straight") {%p277 #"I121":5};
//   %wire_464 = &"POC" @WIRE(mode="straight") {%p282 #"I111":5};
//   %p300 = (483, -417);
//   %wire_465 = &"POC" @WIRE(mode="straight") {%p284 %p300};
//   %p301 = (483, 58);
//   %wire_466 = &"POC" @WIRE(mode="straight") {%p273 %p301};
//   %wire_467 = &"POC" @WIRE(mode="straight") {%p301 #"I60":1};
//   %wire_468 = &"POC" @WIRE(mode="straight") {%p297 #"I88":5};
//   %wire_469 = &"POC" @WIRE(mode="straight") {%p276 #"I126":5};
//   %wire_470 = &"POC" @WIRE(mode="straight") {%p283 %p300};
//   %wire_471 = &"POC" @WIRE(mode="straight") {#"I24":1 %p293};
//   %p302 = (18, -417);
//   %wire_472 = &"POC" @WIRE(mode="straight") {%p302 #"I85":1};
//   %wire_473 = &"POC" @WIRE(mode="straight") {%p280 #"I118":5};
//   %wire_474 = &"POC" @WIRE(mode="straight") {%p299 %p302};
//   %wire_475 = &"POC" @WIRE(mode="straight") {%p279 #"I117":5};
//   %wire_476 = &"POC" @WIRE(mode="straight") {%p302 %p298};
//   %p303 = (382, 95);
//   %wire_477 = &"POC" @WIRE(mode="straight") {#"I55":1 %p303};
//   %wire_478 = &"POC" @WIRE(mode="straight") {%p294 %p295};
//   %wire_479 = &"POC" @WIRE(mode="straight") {%p303 %p293};
//   %wire_480 = &"POC" @WIRE(mode="straight") {%p295 %p301};
//   %p304 = (-39, -417);
//   %wire_481 = &"POC" @WIRE(mode="straight") {%p304 #"I153":1};
//   %wire_482 = &"POC" @WIRE(mode="straight") {%p281 #"I114":5};
//   %wire_483 = &"POC" @WIRE(mode="straight") {%p272 #"I129":5};
//   %wire_484 = &"POC" @WIRE(mode="straight") {%p298 %p296};
//   %wire_485 = &"POC" @WIRE(mode="straight") {%p304 %p299};
//   %wire_486 = &"POC" @WIRE(mode="straight") {%p273 #"I132":5};
//   %wire_487 = &"POC" @WIRE(mode="straight") {%p285 #"I107":5};
//   %wire_488 = &"POC" @WIRE(mode="straight") {%p296 #"I87":5};
//   %wire_489 = &"POC" @WIRE(mode="straight") {%p274 #"I130":5};
//   %wire_466 @TEXT("POC", size=1, halign="middle", valign="top", rotate=90) => @PLACE(483.7, 47);
//   %wire_490 = &"net8" @WIRE(mode="straight") {%marker_8 #"I114":1};
//   %wire_491 = &"D3_CORE" @WIRE(mode="straight") {#"I106":2 %port_91::pin};
//   %p305 = (-150, -52);
//   %wire_492 = &"GNDA_CORE" @WIRE(mode="straight") {#"I76":1 %p305};
//   %p306 = (-150, -141);
//   %wire_493 = &"GNDA_CORE" @WIRE(mode="straight") {#"I77":1 %p306};
//   %p307 = (-150, -229);
//   %wire_494 = &"GNDA_CORE" @WIRE(mode="straight") {#"I63":1 %p307};
//   %p308 = (46, 78);
//   %wire_495 = &"GNDA_CORE" @WIRE(mode="straight") {%p308 #"I133":1};
//   %p309 = (-150, -263);
//   %wire_496 = &"GNDA_CORE" @WIRE(mode="straight") {#"I152":1 %p309};
//   %p310 = (-150, 55);
//   %wire_497 = &"GNDA_CORE" @WIRE(mode="straight") {#"I73":1 %p310};
//   %p311 = (315, 87);
//   %wire_498 = &"GNDA" @WIRE(mode="straight") {#"I147":3 %p311};
//   %p312 = (141, 87);
//   %p313 = (177, 87);
//   %wire_499 = &"GNDA" @WIRE(mode="straight") {%p312 %p313};
//   %p314 = (347, 87);
//   %wire_500 = &"GNDA" @WIRE(mode="straight") {#"I146":3 %p314};
//   %p315 = (214, 87);
//   %wire_501 = &"GNDA" @WIRE(mode="straight") {%p313 %p315};
//   %wire_502 = &"GNDA" @WIRE(mode="straight") {%p311 %p314};
//   %p316 = (282, 87);
//   %wire_503 = &"GNDA" @WIRE(mode="straight") {#"I145":3 %p316};
//   %p317 = (248, 87);
//   %wire_504 = &"GNDA" @WIRE(mode="straight") {#"I144":3 %p317};
//   %p318 = (-89, 87);
//   %wire_505 = &"GNDA" @WIRE(mode="straight") {#"I160":3 %p318};
//   %p319 = (-159, 87);
//   %p320 = (-117, 87);
//   %wire_506 = &"GNDA" @WIRE(mode="straight") {%p319 %p320};
//   %wire_507 = &"GNDA" @WIRE(mode="straight") {%p320 %p318};
//   %p321 = (-188, 48);
//   %wire_508 = &"GNDA" @WIRE(mode="straight") {%p321 #"I73":3};
//   %wire_509 = &"GNDA" @WIRE(mode="straight") {%p316 %p311};
//   %p322 = (-188, 39);
//   %wire_510 = &"GNDA" @WIRE(mode="straight") {%p322 %p321};
//   %p323 = (-188, -148);
//   %wire_511 = &"GNDA" @WIRE(mode="straight") {%p323 #"I77":3};
//   %p324 = (-197, -148);
//   %wire_512 = &"GNDA" @WIRE(mode="straight") {%p324 %port_61::pin %p323};
//   %p325 = (-159, -157);
//   %p326 = (-188, -157);
//   %wire_513 = &"GNDA" @WIRE(mode="straight") {%p325 %p326};
//   %p327 = (-159, -21);
//   %wire_514 = &"GNDA" @WIRE(mode="straight") {#"I75":3 %p327};
//   %p328 = (-188, -279);
//   %p329 = (-188, -270);
//   %wire_515 = &"GNDA" @WIRE(mode="straight") {%p328 %p329};
//   %p330 = (-197, -270);
//   %wire_516 = &"GNDA" @WIRE(mode="straight") {%p330 %port_59::pin %p329};
//   %p331 = (39, 125);
//   %p332 = (39, 116);
//   %wire_517 = &"GNDA" @WIRE(mode="straight") {%p331 %port_60::pin %p332};
//   %p333 = (-197, -59);
//   %p334 = (-188, -59);
//   %wire_518 = &"GNDA" @WIRE(mode="straight") {%p333 %port_62::pin %p334};
//   %p335 = (-159, -245);
//   %p336 = (-188, -245);
//   %wire_519 = &"GNDA" @WIRE(mode="straight") {%p335 %p336};
//   %p337 = (-188, -236);
//   %wire_520 = &"GNDA" @WIRE(mode="straight") {%p337 #"I63":3};
//   %p338 = (-159, -279);
//   %wire_521 = &"GNDA" @WIRE(mode="straight") {%p338 %p328};
//   %p339 = (106, 87);
//   %wire_522 = &"GNDA" @WIRE(mode="straight") {#"I137":3 %p339};
//   %wire_523 = &"GNDA" @WIRE(mode="straight") {#"I143":3 %p315};
//   %p340 = (72, 87);
//   %wire_524 = &"GNDA" @WIRE(mode="straight") {%p340 %p339};
//   %p341 = (-58, 87);
//   %wire_525 = &"GNDA" @WIRE(mode="straight") {%p318 %p341};
//   %p342 = (8, 87);
//   %wire_526 = &"GNDA" @WIRE(mode="straight") {#"I139":3 %p342};
//   %wire_527 = &"GNDA" @WIRE(mode="straight") {%p339 %p312};
//   %p343 = (-159, -68);
//   %wire_528 = &"GNDA" @WIRE(mode="straight") {%p325 %p343};
//   %p344 = (-159, 13);
//   %wire_529 = &"GNDA" @WIRE(mode="straight") {%p327 %p344};
//   %wire_530 = &"GNDA" @WIRE(mode="straight") {%p335 %p325};
//   %p345 = (-25, 87);
//   %wire_531 = &"GNDA" @WIRE(mode="straight") {%p341 %p345};
//   %wire_532 = &"GNDA" @WIRE(mode="straight") {%p338 %p335};
//   %p346 = (30, 116);
//   %p347 = (30, 87);
//   %wire_533 = &"GNDA" @WIRE(mode="straight") {%p346 %p347};
//   %wire_534 = &"GNDA" @WIRE(mode="straight") {#"I135":3 %p341};
//   %wire_535 = &"GNDA" @WIRE(mode="straight") {#"I138":3 %p345};
//   %wire_536 = &"GNDA" @WIRE(mode="straight") {#"I142":3 %p313};
//   %wire_537 = &"GNDA" @WIRE(mode="straight") {%p332 #"I133":3};
//   %p348 = (-188, -68);
//   %wire_538 = &"GNDA" @WIRE(mode="straight") {%p348 %p334};
//   %wire_539 = &"GNDA" @WIRE(mode="straight") {%p343 %p348};
//   %wire_540 = &"GNDA" @WIRE(mode="straight") {%p326 %p323};
//   %p349 = (-197, -236);
//   %wire_541 = &"GNDA" @WIRE(mode="straight") {%p349 %port_64::pin %p337};
//   %wire_542 = &"GNDA" @WIRE(mode="straight") {#"I66":3 %p340};
//   %p350 = (-159, 39);
//   %wire_543 = &"GNDA" @WIRE(mode="straight") {%p350 %p319};
//   %wire_544 = &"GNDA" @WIRE(mode="straight") {#"I74":3 %p344};
//   %wire_545 = &"GNDA" @WIRE(mode="straight") {%p334 #"I76":3};
//   %wire_546 = &"GNDA" @WIRE(mode="straight") {#"I141":3 %p312};
//   %wire_547 = &"GNDA" @WIRE(mode="straight") {%p346 %p332};
//   %wire_548 = &"GNDA" @WIRE(mode="straight") {%p317 %p316};
//   %wire_549 = &"GNDA" @WIRE(mode="straight") {%p343 %p327};
//   %wire_550 = &"GNDA" @WIRE(mode="straight") {%p329 #"I152":3};
//   %p351 = (-197, 48);
//   %wire_551 = &"GNDA" @WIRE(mode="straight") {%p351 %port_63::pin %p321};
//   %wire_552 = &"GNDA" @WIRE(mode="straight") {%p336 %p337};
//   %wire_553 = &"GNDA" @WIRE(mode="straight") {%p350 %p322};
//   %wire_554 = &"GNDA" @WIRE(mode="straight") {%p344 %p350};
//   %wire_555 = &"GNDA" @WIRE(mode="straight") {#"I159":3 %p320};
//   %wire_556 = &"GNDA" @WIRE(mode="straight") {%p315 %p317};
//   %wire_557 = &"GNDA" @WIRE(mode="straight") {%p345 %p342};
//   %wire_558 = &"GNDA" @WIRE(mode="straight") {%p342 %p347};
//   %wire_559 = &"GNDA" @WIRE(mode="straight") {%p347 %p340};
//   %p352 = (-188, -22);
//   %wire_560 = &"INCM" @WIRE(mode="straight") {%p352 #"I75":1};
//   %p353 = (-197, -22);
//   %wire_561 = &"INCM" @WIRE(mode="straight") {%p353 %port_17::pin %p352};
//   %p354 = (-188, -31);
//   %wire_562 = &"INCM" @WIRE(mode="straight") {%p352 %p354};
//   %p355 = (-150, -31);
//   %wire_563 = &"INCM" @WIRE(mode="straight") {%p354 %p355};
//   %p356 = (513, 16);
//   %wire_564 = &"DCLK" @WIRE(mode="straight") {#"I132":4 %port_58::pin %p356};
//   %p357 = (-118, 116);
//   %wire_565 = &"GREF" @WIRE(mode="straight") {%p357 #"I159":1};
//   %p358 = (-118, 125);
//   %wire_566 = &"GREF" @WIRE(mode="straight") {%p358 %port_103::pin %p357};
//   %p359 = (-127, 116);
//   %p360 = (-127, 78);
//   %wire_567 = &"GREF" @WIRE(mode="straight") {%p359 %p360};
//   %wire_568 = &"GREF" @WIRE(mode="straight") {%p357 %p359};
//   %p361 = (468, -240);
//   %wire_569 = &"net9" @WIRE(mode="straight") {%p361 #"I117":6};
//   %p362 = (468, -13);
//   %wire_570 = &"net9" @WIRE(mode="straight") {%p362 #"I129":6};
//   %p363 = (468, -353);
//   %wire_571 = &"net9" @WIRE(mode="straight") {%p363 #"I111":6};
//   %p364 = (468, -315);
//   %wire_572 = &"net9" @WIRE(mode="straight") {%p363 %p364};
//   %wire_573 = &"net9" @WIRE(mode="straight") {%p364 #"I114":6};
//   %p365 = (418, -402);
//   %p366 = (468, -402);
//   %wire_574 = &"net9" @WIRE(mode="straight") {%p365 %p366};
//   %wire_575 = &"net9" @WIRE(mode="straight") {#"I109":6 %p365};
//   %p367 = (269, -402);
//   %wire_576 = &"net9" @WIRE(mode="straight") {#"I102":6 %p367};
//   %p368 = (199, -402);
//   %p369 = (232, -402);
//   %wire_577 = &"net9" @WIRE(mode="straight") {%p368 %p369};
//   %wire_578 = &"net9" @WIRE(mode="straight") {#"I91":3 %p368};
//   %p370 = (195, -402);
//   %wire_579 = &"net9" @WIRE(mode="straight") {%p370 %p368};
//   %wire_580 = &"net9" @WIRE(mode="straight") {#"I91":6 %p370};
//   %p371 = (126, -402);
//   %p372 = (158, -402);
//   %wire_581 = &"net9" @WIRE(mode="straight") {%p371 %p372};
//   %p373 = (90, -402);
//   %p374 = (122, -402);
//   %wire_582 = &"net9" @WIRE(mode="straight") {%p373 %p374};
//   %p375 = (53, -402);
//   %p376 = (86, -402);
//   %wire_583 = &"net9" @WIRE(mode="straight") {%p375 %p376};
//   %wire_584 = &"net9" @WIRE(mode="straight") {#"I89":6 %p372};
//   %wire_585 = &"net9" @WIRE(mode="straight") {%p372 %p370};
//   %p377 = (343, -402);
//   %wire_586 = &"net9" @WIRE(mode="straight") {#"I106":6 %p377};
//   %wire_587 = &"net9" @WIRE(mode="straight") {#"I99":6 %p369};
//   %wire_588 = &"net9" @WIRE(mode="straight") {%p366 %p363};
//   %wire_589 = &"net9" @WIRE(mode="straight") {#"I88":3 %p371};
//   %wire_590 = &"net9" @WIRE(mode="straight") {%p374 %p371};
//   %p378 = (306, -402);
//   %wire_591 = &"net9" @WIRE(mode="straight") {#"I103":6 %p378};
//   %p379 = (468, -278);
//   %wire_592 = &"net9" @WIRE(mode="straight") {%p379 %p361};
//   %p380 = (380, -402);
//   %wire_593 = &"net9" @WIRE(mode="straight") {%p380 %p365};
//   %p381 = (468, -89);
//   %wire_594 = &"net9" @WIRE(mode="straight") {%p381 #"I125":6};
//   %wire_595 = &"net9" @WIRE(mode="straight") {#"I88":6 %p374};
//   %p382 = (468, 25);
//   %wire_596 = &"net9" @WIRE(mode="straight") {%p362 %p382};
//   %p383 = (468, -51);
//   %wire_597 = &"net9" @WIRE(mode="straight") {%p381 %p383};
//   %p384 = (49, -402);
//   %wire_598 = &"net9" @WIRE(mode="straight") {%p384 %p375};
//   %wire_599 = &"net9" @WIRE(mode="straight") {#"I86":3 %p375};
//   %wire_600 = &"net9" @WIRE(mode="straight") {%p367 %p378};
//   %wire_601 = &"net9" @WIRE(mode="straight") {%p369 %p367};
//   %p385 = (468, -202);
//   %wire_602 = &"net9" @WIRE(mode="straight") {%p385 #"I123":6};
//   %p386 = (468, -164);
//   %p387 = (468, -127);
//   %wire_603 = &"net9" @WIRE(mode="straight") {%p386 %p387};
//   %wire_604 = &"net9" @WIRE(mode="straight") {%p386 #"I121":6};
//   %wire_605 = &"net9" @WIRE(mode="straight") {%p385 %p386};
//   %wire_606 = &"net9" @WIRE(mode="straight") {%p387 %p381};
//   %wire_607 = &"net9" @WIRE(mode="straight") {%p387 #"I126":6};
//   %wire_608 = &"net9" @WIRE(mode="straight") {%p364 %p379};
//   %wire_609 = &"net9" @WIRE(mode="straight") {%p382 #"I132":6};
//   %wire_610 = &"net9" @WIRE(mode="straight") {%p383 %p362};
//   %wire_611 = &"net9" @WIRE(mode="straight") {%p378 %p377};
//   %wire_612 = &"net9" @WIRE(mode="straight") {%p377 %p380};
//   %wire_613 = &"net9" @WIRE(mode="straight") {%p361 %p385};
//   %p388 = (468, 79);
//   %wire_614 = &"net9" @WIRE(mode="straight") {%p382 %p388};
//   %wire_615 = &"net9" @WIRE(mode="straight") {#"R0":2 %p388};
//   %wire_616 = &"net9" @WIRE(mode="straight") {#"I86":6 %p384};
//   %wire_617 = &"net9" @WIRE(mode="straight") {%p383 #"I130":6};
//   %wire_618 = &"net9" @WIRE(mode="straight") {#"I87":3 %p373};
//   %wire_619 = &"net9" @WIRE(mode="straight") {%p376 %p373};
//   %wire_620 = &"net9" @WIRE(mode="straight") {%p379 #"I118":6};
//   %wire_621 = &"net9" @WIRE(mode="straight") {#"I87":6 %p376};
//   %wire_622 = &"net9" @WIRE(mode="straight") {#"I107":6 %p380};
//   %wire_623 = &"net10" @WIRE(mode="straight") {%marker_36 #"I118":1};
//   %wire_624 = &"D1_CORE" @WIRE(mode="straight") {#"I102":2 %port_86::pin};
//   %p389 = (96, 116);
//   %p390 = (96, 78);
//   %wire_625 = &"VCM" @WIRE(mode="straight") {%p389 %p390};
//   %p391 = (105, 116);
//   %wire_626 = &"VCM" @WIRE(mode="straight") {%p391 #"I137":1};
//   %wire_627 = &"VCM" @WIRE(mode="straight") {%p391 %p389};
//   %p392 = (105, 125);
//   %wire_628 = &"VCM" @WIRE(mode="straight") {%p392 %port_105::pin %p391};
//   %p393 = (472, -32);
//   %p394 = (472, 6);
//   %wire_629 = &"GIOH" @WIRE(mode="straight") {%p393 %p394};
//   %p395 = (472, -70);
//   %wire_630 = &"GIOH" @WIRE(mode="straight") {%p395 %p393};
//   %p396 = (472, -108);
//   %wire_631 = &"GIOH" @WIRE(mode="straight") {%p396 %p395};
//   %p397 = (472, -146);
//   %wire_632 = &"GIOH" @WIRE(mode="straight") {%p397 %p396};
//   %p398 = (472, -183);
//   %wire_633 = &"GIOH" @WIRE(mode="straight") {%p398 %p397};
//   %p399 = (472, -221);
//   %wire_634 = &"GIOH" @WIRE(mode="straight") {%p399 %p398};
//   %p400 = (472, -259);
//   %wire_635 = &"GIOH" @WIRE(mode="straight") {%p400 %p399};
//   %p401 = (472, -297);
//   %wire_636 = &"GIOH" @WIRE(mode="straight") {%p401 %p400};
//   %p402 = (472, -334);
//   %wire_637 = &"GIOH" @WIRE(mode="straight") {%p402 %p401};
//   %p403 = (472, -372);
//   %wire_638 = &"GIOH" @WIRE(mode="straight") {%p403 %p402};
//   %p404 = (433, -406);
//   %p405 = (472, -406);
//   %wire_639 = &"GIOH" @WIRE(mode="straight") {%p404 %p405};
//   %p406 = (445, -438);
//   %wire_640 = &"GIOH" @WIRE(mode="straight") {%p406 #"I98":5};
//   %p407 = (445, -447);
//   %wire_641 = &"GIOH" @WIRE(mode="straight") {%p407 %port_34::pin %p406};
//   %p408 = (433, -438);
//   %wire_642 = &"GIOH" @WIRE(mode="straight") {%p406 %p408};
//   %wire_643 = &"GIOH" @WIRE(mode="straight") {%p404 %p408};
//   %p409 = (361, -406);
//   %p410 = (399, -406);
//   %wire_644 = &"GIOH" @WIRE(mode="straight") {%p409 %p410};
//   %wire_645 = &"GIOH" @WIRE(mode="straight") {%p402 #"I114":10};
//   %wire_646 = &"GIOH" @WIRE(mode="straight") {%p410 %p404};
//   %p411 = (287, -406);
//   %wire_647 = &"GIOH" @WIRE(mode="straight") {%p411 #"I103":10};
//   %wire_648 = &"GIOH" @WIRE(mode="straight") {%p410 #"I109":10};
//   %p412 = (250, -406);
//   %wire_649 = &"GIOH" @WIRE(mode="straight") {%p412 #"I102":10};
//   %p413 = (176, -406);
//   %p414 = (213, -406);
//   %wire_650 = &"GIOH" @WIRE(mode="straight") {%p413 %p414};
//   %wire_651 = &"GIOH" @WIRE(mode="straight") {%p413 #"I91":10};
//   %p415 = (324, -406);
//   %wire_652 = &"GIOH" @WIRE(mode="straight") {%p415 #"I106":10};
//   %p416 = (139, -406);
//   %wire_653 = &"GIOH" @WIRE(mode="straight") {%p416 #"I89":10};
//   %p417 = (103, -406);
//   %wire_654 = &"GIOH" @WIRE(mode="straight") {%p417 %p416};
//   %p418 = (-25, -406);
//   %wire_655 = &"GIOH" @WIRE(mode="straight") {%p418 #"I84":5};
//   %wire_656 = &"GIOH" @WIRE(mode="straight") {%p403 #"I111":10};
//   %wire_657 = &"GIOH" @WIRE(mode="straight") {%p401 #"I118":10};
//   %p419 = (472, 43);
//   %wire_658 = &"GIOH" @WIRE(mode="straight") {%p394 %p419};
//   %p420 = (30, -406);
//   %wire_659 = &"GIOH" @WIRE(mode="straight") {%p420 #"I86":10};
//   %wire_660 = &"GIOH" @WIRE(mode="straight") {%p419 #"I60":5};
//   %p421 = (8, -438);
//   %p422 = (-4, -438);
//   %wire_661 = &"GIOH" @WIRE(mode="straight") {%p421 %p422};
//   %p423 = (8, -447);
//   %wire_662 = &"GIOH" @WIRE(mode="straight") {%p423 %port_35::pin %p421};
//   %wire_663 = &"GIOH" @WIRE(mode="straight") {%p393 #"I129":10};
//   %wire_664 = &"GIOH" @WIRE(mode="straight") {%p409 #"I107":10};
//   %p424 = (67, -406);
//   %wire_665 = &"GIOH" @WIRE(mode="straight") {%p424 #"I87":10};
//   %p425 = (472, 63);
//   %wire_666 = &"GIOH" @WIRE(mode="straight") {%p425 %p419};
//   %p426 = (504, 63);
//   %wire_667 = &"GIOH" @WIRE(mode="straight") {%p425 %p426};
//   %p427 = (504, 75);
//   %wire_668 = &"GIOH" @WIRE(mode="straight") {%p427 %p426};
//   %wire_669 = &"GIOH" @WIRE(mode="straight") {%p427 #"I58":5};
//   %p428 = (513, 75);
//   %wire_670 = &"GIOH" @WIRE(mode="straight") {%p428 %port_32::pin %p427};
//   %p429 = (-4, -406);
//   %wire_671 = &"GIOH" @WIRE(mode="straight") {%p429 %p422};
//   %p430 = (504, -406);
//   %wire_672 = &"GIOH" @WIRE(mode="straight") {%p405 %p430};
//   %wire_673 = &"GIOH" @WIRE(mode="straight") {%p411 %p415};
//   %wire_674 = &"GIOH" @WIRE(mode="straight") {%p400 #"I117":10};
//   %wire_675 = &"GIOH" @WIRE(mode="straight") {%p399 #"I123":10};
//   %wire_676 = &"GIOH" @WIRE(mode="straight") {%p398 #"I121":10};
//   %p431 = (-54, -406);
//   %wire_677 = &"GIOH" @WIRE(mode="straight") {%p431 %p418};
//   %wire_678 = &"GIOH" @WIRE(mode="straight") {%p420 %p424};
//   %wire_679 = &"GIOH" @WIRE(mode="straight") {%p412 %p411};
//   %wire_680 = &"GIOH" @WIRE(mode="straight") {%p414 %p412};
//   %wire_681 = &"GIOH" @WIRE(mode="straight") {%p416 %p413};
//   %wire_682 = &"GIOH" @WIRE(mode="straight") {%p405 %p403};
//   %wire_683 = &"GIOH" @WIRE(mode="straight") {%p397 #"I126":10};
//   %wire_684 = &"GIOH" @WIRE(mode="straight") {%p424 %p417};
//   %wire_685 = &"GIOH" @WIRE(mode="straight") {%p395 #"I130":10};
//   %wire_686 = &"GIOH" @WIRE(mode="straight") {%p394 #"I132":10};
//   %wire_687 = &"GIOH" @WIRE(mode="straight") {%p429 %p420};
//   %wire_688 = &"GIOH" @WIRE(mode="straight") {%p415 %p409};
//   %wire_689 = &"GIOH" @WIRE(mode="straight") {%p418 %p429};
//   %p432 = (513, -394);
//   %p433 = (504, -394);
//   %wire_690 = &"GIOH" @WIRE(mode="straight") {%p432 %port_33::pin %p433};
//   %wire_691 = &"GIOH" @WIRE(mode="straight") {%p433 %p430};
//   %wire_692 = &"GIOH" @WIRE(mode="straight") {%p433 #"I56":5};
//   %p434 = (397, 84);
//   %wire_693 = &"GIOH" @WIRE(mode="straight") {%p434 #"I55":5};
//   %wire_694 = &"GIOH" @WIRE(mode="straight") {%p414 #"I99":10};
//   %wire_695 = &"GIOH" @WIRE(mode="straight") {%p396 #"I125":10};
//   %wire_696 = &"GIOH" @WIRE(mode="straight") {%p417 #"I88":10};
//   %wire_697 = &"GIOH" @WIRE(mode="straight") {%p421 #"I85":5};
//   %wire_698 = &"GIOH" @WIRE(mode="straight") {%p431 #"I153":5};
//   %p435 = (472, 84);
//   %wire_699 = &"GIOH" @WIRE(mode="straight") {%p425 %p435};
//   %p436 = (427, 84);
//   %wire_700 = &"GIOH" @WIRE(mode="straight") {#"I24":5 %p436};
//   %wire_701 = &"GIOH" @WIRE(mode="straight") {%p436 %p435};
//   %wire_702 = &"GIOH" @WIRE(mode="straight") {%p434 %p436};
//   %wire_703 = &"net11" @WIRE(mode="straight") {%marker_74 #"I111":1};
//   %p437 = (457, -7);
//   %wire_704 = &"D15_CORE" @WIRE(mode="straight") {%p437 %port_24::pin #"I129":2};
//   %wire_705 = &"net12" @WIRE(mode="straight") {#"I106":1 %marker_1};
//   %p438 = (7, 116);
//   %wire_706 = &"VDIG" @WIRE(mode="straight") {#"I139":1 %p438};
//   %p439 = (-2, 75);
//   %p440 = (-2, 116);
//   %wire_707 = &"VDIG" @WIRE(mode="straight") {%p439 %port_71::pin %p440};
//   %wire_708 = &"VDIG" @WIRE(mode="straight") {%p440 %p438};
//   %p441 = (7, 125);
//   %wire_709 = &"VDIG" @WIRE(mode="straight") {%p438 %port_72::pin %p441};
//   %wire_710 = &"net13" @WIRE(mode="straight") {#"I107":1 %marker_28};
//   %p442 = (475, -20);
//   %p443 = (475, 18);
//   %wire_711 = &"VIOL" @WIRE(mode="straight") {%p442 %p443};
//   %p444 = (475, -58);
//   %wire_712 = &"VIOL" @WIRE(mode="straight") {%p444 %p442};
//   %p445 = (475, -96);
//   %wire_713 = &"VIOL" @WIRE(mode="straight") {%p445 %p444};
//   %p446 = (475, -134);
//   %wire_714 = &"VIOL" @WIRE(mode="straight") {%p446 %p445};
//   %p447 = (475, -171);
//   %wire_715 = &"VIOL" @WIRE(mode="straight") {%p447 %p446};
//   %p448 = (475, -209);
//   %wire_716 = &"VIOL" @WIRE(mode="straight") {%p448 %p447};
//   %p449 = (475, -247);
//   %wire_717 = &"VIOL" @WIRE(mode="straight") {%p449 %p448};
//   %p450 = (475, -285);
//   %wire_718 = &"VIOL" @WIRE(mode="straight") {%p450 %p449};
//   %p451 = (475, -322);
//   %wire_719 = &"VIOL" @WIRE(mode="straight") {%p451 %p450};
//   %p452 = (475, -360);
//   %wire_720 = &"VIOL" @WIRE(mode="straight") {%p452 %p451};
//   %p453 = (475, -387);
//   %wire_721 = &"VIOL" @WIRE(mode="straight") {%p453 %p452};
//   %p454 = (452, -409);
//   %wire_722 = &"VIOL" @WIRE(mode="straight") {#"I98":2 %p454};
//   %p455 = (373, -409);
//   %p456 = (411, -409);
//   %wire_723 = &"VIOL" @WIRE(mode="straight") {%p455 %p456};
//   %p457 = (225, -409);
//   %wire_724 = &"VIOL" @WIRE(mode="straight") {%p457 #"I99":7};
//   %wire_725 = &"VIOL" @WIRE(mode="straight") {%p456 #"I109":7};
//   %wire_726 = &"VIOL" @WIRE(mode="straight") {%p456 %p454};
//   %p458 = (262, -409);
//   %p459 = (299, -409);
//   %wire_727 = &"VIOL" @WIRE(mode="straight") {%p458 %p459};
//   %wire_728 = &"VIOL" @WIRE(mode="straight") {%p458 #"I102":7};
//   %wire_729 = &"VIOL" @WIRE(mode="straight") {%p459 #"I103":7};
//   %p460 = (188, -409);
//   %wire_730 = &"VIOL" @WIRE(mode="straight") {%p460 %p457};
//   %wire_731 = &"VIOL" @WIRE(mode="straight") {%p460 #"I91":7};
//   %p461 = (336, -409);
//   %wire_732 = &"VIOL" @WIRE(mode="straight") {%p461 #"I106":7};
//   %p462 = (151, -409);
//   %wire_733 = &"VIOL" @WIRE(mode="straight") {%p462 #"I89":7};
//   %p463 = (-13, -409);
//   %wire_734 = &"VIOL" @WIRE(mode="straight") {#"I84":2 %p463};
//   %p464 = (475, 55);
//   %p465 = (475, 82);
//   %wire_735 = &"VIOL" @WIRE(mode="straight") {%p464 %p465};
//   %wire_736 = &"VIOL" @WIRE(mode="straight") {%p461 %p455};
//   %p466 = (422, 87);
//   %p467 = (433, 87);
//   %wire_737 = &"VIOL" @WIRE(mode="straight") {%p466 %p467};
//   %wire_738 = &"VIOL" @WIRE(mode="straight") {%p451 #"I114":7};
//   %p468 = (42, -409);
//   %wire_739 = &"VIOL" @WIRE(mode="straight") {%p468 #"I86":7};
//   %p469 = (115, -409);
//   %wire_740 = &"VIOL" @WIRE(mode="straight") {%p469 %p462};
//   %wire_741 = &"VIOL" @WIRE(mode="straight") {%p455 #"I107":7};
//   %p470 = (15, -409);
//   %wire_742 = &"VIOL" @WIRE(mode="straight") {%p463 %p470};
//   %wire_743 = &"VIOL" @WIRE(mode="straight") {%p459 %p461};
//   %wire_744 = &"VIOL" @WIRE(mode="straight") {%p452 #"I111":7};
//   %wire_745 = &"VIOL" @WIRE(mode="straight") {%p449 #"I117":7};
//   %wire_746 = &"VIOL" @WIRE(mode="straight") {%p450 #"I118":7};
//   %wire_747 = &"VIOL" @WIRE(mode="straight") {%p448 #"I123":7};
//   %wire_748 = &"VIOL" @WIRE(mode="straight") {%p443 #"I132":7};
//   %wire_749 = &"VIOL" @WIRE(mode="straight") {%p447 #"I121":7};
//   %wire_750 = &"VIOL" @WIRE(mode="straight") {%p442 #"I129":7};
//   %wire_751 = &"VIOL" @WIRE(mode="straight") {%p470 %p468};
//   %wire_752 = &"VIOL" @WIRE(mode="straight") {%p469 #"I88":7};
//   %p471 = (445, 87);
//   %p472 = (475, 87);
//   %wire_753 = &"VIOL" @WIRE(mode="straight") {%p471 %p472};
//   %wire_754 = &"VIOL" @WIRE(mode="straight") {%p446 #"I126":7};
//   %p473 = (475, -409);
//   %wire_755 = &"VIOL" @WIRE(mode="straight") {%p453 %p473};
//   %p474 = (432, 125);
//   %p475 = (432, 116);
//   %wire_756 = &"VIOL" @WIRE(mode="straight") {%p474 %port_23::pin %p475};
//   %p476 = (422, 75);
//   %p477 = (422, 79);
//   %wire_757 = &"VIOL" @WIRE(mode="straight") {%p476 %p477};
//   %p478 = (445, 116);
//   %wire_758 = &"VIOL" @WIRE(mode="straight") {%p478 %p471};
//   %wire_759 = &"VIOL" @WIRE(mode="straight") {%p475 #"I24":2};
//   %wire_760 = &"VIOL" @WIRE(mode="straight") {%p475 %p478};
//   %wire_761 = &"VIOL" @WIRE(mode="straight") {#"I24":3 %p467};
//   %wire_762 = &"VIOL" @WIRE(mode="straight") {%p467 %p471};
//   %wire_763 = &"VIOL" @WIRE(mode="straight") {#"I85":2 %p470};
//   %wire_764 = &"VIOL" @WIRE(mode="straight") {%p454 %p473};
//   %wire_765 = &"VIOL" @WIRE(mode="straight") {#"I56":2 %p453};
//   %wire_766 = &"VIOL" @WIRE(mode="straight") {#"I58":2 %p465};
//   %p479 = (385, 87);
//   %wire_767 = &"VIOL" @WIRE(mode="straight") {%p479 %p466};
//   %wire_768 = &"VIOL" @WIRE(mode="straight") {%p464 #"I60":2};
//   %wire_769 = &"VIOL" @WIRE(mode="straight") {#"I55":2 %p479};
//   %wire_770 = &"VIOL" @WIRE(mode="straight") {%p465 %p472};
//   %wire_771 = &"VIOL" @WIRE(mode="straight") {%p457 %p458};
//   %p480 = (79, -409);
//   %wire_772 = &"VIOL" @WIRE(mode="straight") {%p468 %p480};
//   %wire_773 = &"VIOL" @WIRE(mode="straight") {%p462 %p460};
//   %p481 = (-42, -409);
//   %wire_774 = &"VIOL" @WIRE(mode="straight") {%p481 %p463};
//   %wire_775 = &"VIOL" @WIRE(mode="straight") {%p477 #"R0":1};
//   %wire_776 = &"VIOL" @WIRE(mode="straight") {%p445 #"I125":7};
//   %wire_777 = &"VIOL" @WIRE(mode="straight") {%p480 %p469};
//   %wire_778 = &"VIOL" @WIRE(mode="straight") {%p480 #"I87":7};
//   %wire_779 = &"VIOL" @WIRE(mode="straight") {#"I153":2 %p481};
//   %wire_780 = &"VIOL" @WIRE(mode="straight") {%p477 %p466};
//   %wire_781 = &"VIOL" @WIRE(mode="straight") {%p443 %p464};
//   %wire_782 = &"VIOL" @WIRE(mode="straight") {%p444 #"I130":7};
//   %wire_783 = &"net14" @WIRE(mode="straight") {%marker_18 #"I117":1};
//   %wire_784 = &"net15" @WIRE(mode="straight") {%marker_47 #"I123":1};
//   %p482 = (-150, -311);
//   %wire_785 = &"GCKB_CORE" @WIRE(mode="straight") {#"I155":1 %p482};
//   %p483 = (-136, -400);
//   %wire_786 = &"GCKB_CORE" @WIRE(mode="straight") {#"I156":1 %p483};
//   %wire_787 = &"net16" @WIRE(mode="straight") {%marker_22 #"I121":1};
//   %wire_788 = &"net17" @WIRE(mode="straight") {%marker_38 #"I126":1};
//   %wire_789 = &"net18" @WIRE(mode="straight") {%marker_37 #"I125":1};
//   %wire_790 = &"net19" @WIRE(mode="straight") {%marker_64 #"I130":1};
//   %wire_791 = &"net20" @WIRE(mode="straight") {%marker_3 #"I129":1};
//   %wire_792 = &"net21" @WIRE(mode="straight") {%marker_61 #"I132":1};
//   %wire_793 = &"net22" @WIRE(mode="straight") {#"I99":1 %marker_50};
//   %wire_794 = &"net23" @WIRE(mode="straight") {#"I109":1 %marker_44};
//   %p484 = (457, -45);
//   %wire_795 = &"D14_CORE" @WIRE(mode="straight") {%p484 %port_43::pin #"I130":2};
//   $JUNCTION @ATTACH %p3 => @PLACE(140, 116);
//   $JUNCTION @ATTACH %p8 => @PLACE(-59, 116);
//   $JUNCTION @ATTACH %p15 => @PLACE(247, 116);
//   $JUNCTION @ATTACH %p19 => @PLACE(281, 116);
//   $JUNCTION @ATTACH %p26 => @PLACE(176, 116);
//   $JUNCTION @ATTACH %p33 => @PLACE(213, 116);
//   $JUNCTION @ATTACH %p39 => @PLACE(-188, -377);
//   $JUNCTION @ATTACH %p44 => @PLACE(-188, -348);
//   $JUNCTION @ATTACH %p50 => @PLACE(314, 116);
//   $JUNCTION @ATTACH %p60 => @PLACE(346, 116);
//   $JUNCTION @ATTACH %p64 => @PLACE(-130, -412);
//   $JUNCTION @ATTACH %p66 => @PLACE(-162, -370);
//   $JUNCTION @ATTACH %p67 => @PLACE(-162, -341);
//   $JUNCTION @ATTACH %p71 => @PLACE(-98, -438);
//   $JUNCTION @ATTACH %p77 => @PLACE(395, 93);
//   $JUNCTION @ATTACH %p78 => @PLACE(404, 93);
//   $JUNCTION @ATTACH %p79 => @PLACE(-165, -323);
//   $JUNCTION @ATTACH %p80 => @PLACE(-165, -275);
//   $JUNCTION @ATTACH %p81 => @PLACE(309, 93);
//   $JUNCTION @ATTACH %p82 => @PLACE(78, 93);
//   $JUNCTION @ATTACH %p83 => @PLACE(100, 93);
//   $JUNCTION @ATTACH %p84 => @PLACE(341, 93);
//   $JUNCTION @ATTACH %p85 => @PLACE(276, 93);
//   $JUNCTION @ATTACH %p86 => @PLACE(242, 93);
//   $JUNCTION @ATTACH %p87 => @PLACE(481, 15);
//   $JUNCTION @ATTACH %p88 => @PLACE(481, 52);
//   $JUNCTION @ATTACH %p89 => @PLACE(481, -23);
//   $JUNCTION @ATTACH %p90 => @PLACE(481, -61);
//   $JUNCTION @ATTACH %p91 => @PLACE(481, -99);
//   $JUNCTION @ATTACH %p92 => @PLACE(481, -137);
//   $JUNCTION @ATTACH %p93 => @PLACE(481, -174);
//   $JUNCTION @ATTACH %p94 => @PLACE(481, -212);
//   $JUNCTION @ATTACH %p95 => @PLACE(481, -250);
//   $JUNCTION @ATTACH %p96 => @PLACE(481, -288);
//   $JUNCTION @ATTACH %p97 => @PLACE(481, -325);
//   $JUNCTION @ATTACH %p98 => @PLACE(481, -363);
//   $JUNCTION @ATTACH %p99 => @PLACE(481, -390);
//   $JUNCTION @ATTACH %p100 => @PLACE(395, 81);
//   $JUNCTION @ATTACH %p101 => @PLACE(436, 93);
//   $JUNCTION @ATTACH %p103 => @PLACE(449, -415);
//   $JUNCTION @ATTACH %p104 => @PLACE(370, -415);
//   $JUNCTION @ATTACH %p105 => @PLACE(408, -415);
//   $JUNCTION @ATTACH %p106 => @PLACE(-93, -415);
//   $JUNCTION @ATTACH %p107 => @PLACE(-61, -415);
//   $JUNCTION @ATTACH %p108 => @PLACE(296, -415);
//   $JUNCTION @ATTACH %p109 => @PLACE(333, -415);
//   $JUNCTION @ATTACH %p110 => @PLACE(222, -415);
//   $JUNCTION @ATTACH %p111 => @PLACE(259, -415);
//   $JUNCTION @ATTACH %p112 => @PLACE(185, -415);
//   $JUNCTION @ATTACH %p113 => @PLACE(148, -415);
//   $JUNCTION @ATTACH %p114 => @PLACE(112, -415);
//   $JUNCTION @ATTACH %p115 => @PLACE(-32, -415);
//   $JUNCTION @ATTACH %p118 => @PLACE(-20, -438);
//   $JUNCTION @ATTACH %p119 => @PLACE(-165, -353);
//   $JUNCTION @ATTACH %p120 => @PLACE(-165, -382);
//   $JUNCTION @ATTACH %p121 => @PLACE(-165, -241);
//   $JUNCTION @ATTACH %p122 => @PLACE(-165, -64);
//   $JUNCTION @ATTACH %p123 => @PLACE(-165, -27);
//   $JUNCTION @ATTACH %p125 => @PLACE(-123, 93);
//   $JUNCTION @ATTACH %p127 => @PLACE(-29, -415);
//   $JUNCTION @ATTACH %p128 => @PLACE(12, -415);
//   $JUNCTION @ATTACH %p129 => @PLACE(-165, -153);
//   $JUNCTION @ATTACH %p130 => @PLACE(481, 79);
//   $JUNCTION @ATTACH %p131 => @PLACE(-165, 7);
//   $JUNCTION @ATTACH %p132 => @PLACE(-165, 43);
//   $JUNCTION @ATTACH %p133 => @PLACE(135, 93);
//   $JUNCTION @ATTACH %p134 => @PLACE(208, 93);
//   $JUNCTION @ATTACH %p135 => @PLACE(-58, -415);
//   $JUNCTION @ATTACH %p138 => @PLACE(-64, 93);
//   $JUNCTION @ATTACH %p139 => @PLACE(39, -415);
//   $JUNCTION @ATTACH %p141 => @PLACE(-124, -415);
//   $JUNCTION @ATTACH %p142 => @PLACE(-31, 93);
//   $JUNCTION @ATTACH %p143 => @PLACE(2, 93);
//   $JUNCTION @ATTACH %p144 => @PLACE(76, -415);
//   $JUNCTION @ATTACH %p145 => @PLACE(-95, 93);
//   $JUNCTION @ATTACH %p147 => @PLACE(-49, -438);
//   $JUNCTION @ATTACH %p148 => @PLACE(34, 93);
//   $JUNCTION @ATTACH %p150 => @PLACE(392, 116);
//   $JUNCTION @ATTACH %p154 => @PLACE(171, 93);
//   $JUNCTION @ATTACH %p160 => @PLACE(-26, 116);
//   $JUNCTION @ATTACH %p164 => @PLACE(321, 90);
//   $JUNCTION @ATTACH %p165 => @PLACE(63, 90);
//   $JUNCTION @ATTACH %p166 => @PLACE(112, 90);
//   $JUNCTION @ATTACH %p168 => @PLACE(288, 90);
//   $JUNCTION @ATTACH %p169 => @PLACE(-83, 90);
//   $JUNCTION @ATTACH %p170 => @PLACE(254, 90);
//   $JUNCTION @ATTACH %p172 => @PLACE(40, 90);
//   $JUNCTION @ATTACH %p173 => @PLACE(14, 90);
//   $JUNCTION @ATTACH %p174 => @PLACE(-162, -58);
//   $JUNCTION @ATTACH %p175 => @PLACE(-162, -15);
//   $JUNCTION @ATTACH %p176 => @PLACE(-162, 19);
//   $JUNCTION @ATTACH %p178 => @PLACE(-111, 90);
//   $JUNCTION @ATTACH %p179 => @PLACE(147, 90);
//   $JUNCTION @ATTACH %p180 => @PLACE(183, 90);
//   $JUNCTION @ATTACH %p181 => @PLACE(-52, 90);
//   $JUNCTION @ATTACH %p182 => @PLACE(-19, 90);
//   $JUNCTION @ATTACH %p183 => @PLACE(220, 90);
//   $JUNCTION @ATTACH %p185 => @PLACE(-162, -235);
//   $JUNCTION @ATTACH %p186 => @PLACE(-162, -147);
//   $JUNCTION @ATTACH %p187 => @PLACE(73, 116);
//   $JUNCTION @ATTACH %p188 => @PLACE(-162, 49);
//   $JUNCTION @ATTACH %p190 => @PLACE(470, -9);
//   $JUNCTION @ATTACH %p191 => @PLACE(470, 29);
//   $JUNCTION @ATTACH %p192 => @PLACE(470, -85);
//   $JUNCTION @ATTACH %p193 => @PLACE(470, -47);
//   $JUNCTION @ATTACH %p194 => @PLACE(470, -160);
//   $JUNCTION @ATTACH %p195 => @PLACE(470, -123);
//   $JUNCTION @ATTACH %p196 => @PLACE(470, -236);
//   $JUNCTION @ATTACH %p197 => @PLACE(470, -198);
//   $JUNCTION @ATTACH %p198 => @PLACE(470, -311);
//   $JUNCTION @ATTACH %p199 => @PLACE(470, -274);
//   $JUNCTION @ATTACH %p200 => @PLACE(384, -404);
//   $JUNCTION @ATTACH %p201 => @PLACE(422, -404);
//   $JUNCTION @ATTACH %p203 => @PLACE(470, -349);
//   $JUNCTION @ATTACH %p204 => @PLACE(236, -404);
//   $JUNCTION @ATTACH %p205 => @PLACE(310, -404);
//   $JUNCTION @ATTACH %p206 => @PLACE(347, -404);
//   $JUNCTION @ATTACH %p207 => @PLACE(273, -404);
//   $JUNCTION @ATTACH %p208 => @PLACE(201, -404);
//   $JUNCTION @ATTACH %p209 => @PLACE(128, -404);
//   $JUNCTION @ATTACH %p210 => @PLACE(162, -404);
//   $JUNCTION @ATTACH %p211 => @PLACE(92, -404);
//   $JUNCTION @ATTACH %p217 => @PLACE(-90, 116);
//   $JUNCTION @ATTACH %p223 => @PLACE(-188, 12);
//   $JUNCTION @ATTACH %p225 => @PLACE(478, 12);
//   $JUNCTION @ATTACH %p226 => @PLACE(478, 36);
//   $JUNCTION @ATTACH %p227 => @PLACE(478, -26);
//   $JUNCTION @ATTACH %p228 => @PLACE(478, -64);
//   $JUNCTION @ATTACH %p229 => @PLACE(478, -102);
//   $JUNCTION @ATTACH %p230 => @PLACE(478, -140);
//   $JUNCTION @ATTACH %p231 => @PLACE(478, -177);
//   $JUNCTION @ATTACH %p232 => @PLACE(478, -215);
//   $JUNCTION @ATTACH %p233 => @PLACE(478, -253);
//   $JUNCTION @ATTACH %p234 => @PLACE(478, -291);
//   $JUNCTION @ATTACH %p235 => @PLACE(478, -328);
//   $JUNCTION @ATTACH %p236 => @PLACE(478, -366);
//   $JUNCTION @ATTACH %p237 => @PLACE(478, -393);
//   $JUNCTION @ATTACH %p238 => @PLACE(446, -412);
//   $JUNCTION @ATTACH %p239 => @PLACE(367, -412);
//   $JUNCTION @ATTACH %p240 => @PLACE(405, -412);
//   $JUNCTION @ATTACH %p241 => @PLACE(256, -412);
//   $JUNCTION @ATTACH %p242 => @PLACE(293, -412);
//   $JUNCTION @ATTACH %p243 => @PLACE(330, -412);
//   $JUNCTION @ATTACH %p244 => @PLACE(182, -412);
//   $JUNCTION @ATTACH %p245 => @PLACE(219, -412);
//   $JUNCTION @ATTACH %p246 => @PLACE(145, -412);
//   $JUNCTION @ATTACH %p247 => @PLACE(109, -412);
//   $JUNCTION @ATTACH %p248 => @PLACE(478, 76);
//   $JUNCTION @ATTACH %p250 => @PLACE(504, 48);
//   $JUNCTION @ATTACH %p253 => @PLACE(73, -412);
//   $JUNCTION @ATTACH %p254 => @PLACE(9, -412);
//   $JUNCTION @ATTACH %p255 => @PLACE(36, -412);
//   $JUNCTION @ATTACH %p257 => @PLACE(-19, -412);
//   $JUNCTION @ATTACH %p260 => @PLACE(-120, -409);
//   $JUNCTION @ATTACH %p262 => @PLACE(-159, -376);
//   $JUNCTION @ATTACH %p263 => @PLACE(-159, -347);
//   $JUNCTION @ATTACH %p264 => @PLACE(-188, -318);
//   $JUNCTION @ATTACH %p268 => @PLACE(-129, -438);
//   $JUNCTION @ATTACH %p272 => @PLACE(483, -17);
//   $JUNCTION @ATTACH %p273 => @PLACE(483, 21);
//   $JUNCTION @ATTACH %p274 => @PLACE(483, -55);
//   $JUNCTION @ATTACH %p275 => @PLACE(483, -93);
//   $JUNCTION @ATTACH %p276 => @PLACE(483, -131);
//   $JUNCTION @ATTACH %p277 => @PLACE(483, -168);
//   $JUNCTION @ATTACH %p278 => @PLACE(483, -206);
//   $JUNCTION @ATTACH %p279 => @PLACE(483, -244);
//   $JUNCTION @ATTACH %p280 => @PLACE(483, -282);
//   $JUNCTION @ATTACH %p281 => @PLACE(483, -319);
//   $JUNCTION @ATTACH %p282 => @PLACE(483, -357);
//   $JUNCTION @ATTACH %p283 => @PLACE(483, -384);
//   $JUNCTION @ATTACH %p284 => @PLACE(455, -417);
//   $JUNCTION @ATTACH %p285 => @PLACE(376, -417);
//   $JUNCTION @ATTACH %p286 => @PLACE(414, -417);
//   $JUNCTION @ATTACH %p287 => @PLACE(228, -417);
//   $JUNCTION @ATTACH %p288 => @PLACE(302, -417);
//   $JUNCTION @ATTACH %p289 => @PLACE(339, -417);
//   $JUNCTION @ATTACH %p290 => @PLACE(265, -417);
//   $JUNCTION @ATTACH %p291 => @PLACE(191, -417);
//   $JUNCTION @ATTACH %p292 => @PLACE(154, -417);
//   $JUNCTION @ATTACH %p293 => @PLACE(442, 95);
//   $JUNCTION @ATTACH %p295 => @PLACE(483, 85);
//   $JUNCTION @ATTACH %p296 => @PLACE(82, -417);
//   $JUNCTION @ATTACH %p297 => @PLACE(118, -417);
//   $JUNCTION @ATTACH %p298 => @PLACE(45, -417);
//   $JUNCTION @ATTACH %p299 => @PLACE(-10, -417);
//   $JUNCTION @ATTACH %p301 => @PLACE(483, 58);
//   $JUNCTION @ATTACH %p302 => @PLACE(18, -417);
//   $JUNCTION @ATTACH %p311 => @PLACE(315, 87);
//   $JUNCTION @ATTACH %p312 => @PLACE(141, 87);
//   $JUNCTION @ATTACH %p313 => @PLACE(177, 87);
//   $JUNCTION @ATTACH %p315 => @PLACE(214, 87);
//   $JUNCTION @ATTACH %p316 => @PLACE(282, 87);
//   $JUNCTION @ATTACH %p317 => @PLACE(248, 87);
//   $JUNCTION @ATTACH %p318 => @PLACE(-89, 87);
//   $JUNCTION @ATTACH %p320 => @PLACE(-117, 87);
//   $JUNCTION @ATTACH %p321 => @PLACE(-188, 48);
//   $JUNCTION @ATTACH %p323 => @PLACE(-188, -148);
//   $JUNCTION @ATTACH %p325 => @PLACE(-159, -157);
//   $JUNCTION @ATTACH %p327 => @PLACE(-159, -21);
//   $JUNCTION @ATTACH %p329 => @PLACE(-188, -270);
//   $JUNCTION @ATTACH %p332 => @PLACE(39, 116);
//   $JUNCTION @ATTACH %p334 => @PLACE(-188, -59);
//   $JUNCTION @ATTACH %p335 => @PLACE(-159, -245);
//   $JUNCTION @ATTACH %p337 => @PLACE(-188, -236);
//   $JUNCTION @ATTACH %p339 => @PLACE(106, 87);
//   $JUNCTION @ATTACH %p340 => @PLACE(72, 87);
//   $JUNCTION @ATTACH %p341 => @PLACE(-58, 87);
//   $JUNCTION @ATTACH %p342 => @PLACE(8, 87);
//   $JUNCTION @ATTACH %p343 => @PLACE(-159, -68);
//   $JUNCTION @ATTACH %p344 => @PLACE(-159, 13);
//   $JUNCTION @ATTACH %p345 => @PLACE(-25, 87);
//   $JUNCTION @ATTACH %p347 => @PLACE(30, 87);
//   $JUNCTION @ATTACH %p350 => @PLACE(-159, 39);
//   $JUNCTION @ATTACH %p352 => @PLACE(-188, -22);
//   $JUNCTION @ATTACH %p357 => @PLACE(-118, 116);
//   $JUNCTION @ATTACH %p361 => @PLACE(468, -240);
//   $JUNCTION @ATTACH %p362 => @PLACE(468, -13);
//   $JUNCTION @ATTACH %p363 => @PLACE(468, -353);
//   $JUNCTION @ATTACH %p364 => @PLACE(468, -315);
//   $JUNCTION @ATTACH %p365 => @PLACE(418, -402);
//   $JUNCTION @ATTACH %p367 => @PLACE(269, -402);
//   $JUNCTION @ATTACH %p368 => @PLACE(199, -402);
//   $JUNCTION @ATTACH %p369 => @PLACE(232, -402);
//   $JUNCTION @ATTACH %p370 => @PLACE(195, -402);
//   $JUNCTION @ATTACH %p371 => @PLACE(126, -402);
//   $JUNCTION @ATTACH %p372 => @PLACE(158, -402);
//   $JUNCTION @ATTACH %p373 => @PLACE(90, -402);
//   $JUNCTION @ATTACH %p374 => @PLACE(122, -402);
//   $JUNCTION @ATTACH %p375 => @PLACE(53, -402);
//   $JUNCTION @ATTACH %p376 => @PLACE(86, -402);
//   $JUNCTION @ATTACH %p377 => @PLACE(343, -402);
//   $JUNCTION @ATTACH %p378 => @PLACE(306, -402);
//   $JUNCTION @ATTACH %p379 => @PLACE(468, -278);
//   $JUNCTION @ATTACH %p380 => @PLACE(380, -402);
//   $JUNCTION @ATTACH %p381 => @PLACE(468, -89);
//   $JUNCTION @ATTACH %p382 => @PLACE(468, 25);
//   $JUNCTION @ATTACH %p383 => @PLACE(468, -51);
//   $JUNCTION @ATTACH %p385 => @PLACE(468, -202);
//   $JUNCTION @ATTACH %p386 => @PLACE(468, -164);
//   $JUNCTION @ATTACH %p387 => @PLACE(468, -127);
//   $JUNCTION @ATTACH %p391 => @PLACE(105, 116);
//   $JUNCTION @ATTACH %p393 => @PLACE(472, -32);
//   $JUNCTION @ATTACH %p394 => @PLACE(472, 6);
//   $JUNCTION @ATTACH %p395 => @PLACE(472, -70);
//   $JUNCTION @ATTACH %p396 => @PLACE(472, -108);
//   $JUNCTION @ATTACH %p397 => @PLACE(472, -146);
//   $JUNCTION @ATTACH %p398 => @PLACE(472, -183);
//   $JUNCTION @ATTACH %p399 => @PLACE(472, -221);
//   $JUNCTION @ATTACH %p400 => @PLACE(472, -259);
//   $JUNCTION @ATTACH %p401 => @PLACE(472, -297);
//   $JUNCTION @ATTACH %p402 => @PLACE(472, -334);
//   $JUNCTION @ATTACH %p403 => @PLACE(472, -372);
//   $JUNCTION @ATTACH %p404 => @PLACE(433, -406);
//   $JUNCTION @ATTACH %p405 => @PLACE(472, -406);
//   $JUNCTION @ATTACH %p406 => @PLACE(445, -438);
//   $JUNCTION @ATTACH %p409 => @PLACE(361, -406);
//   $JUNCTION @ATTACH %p410 => @PLACE(399, -406);
//   $JUNCTION @ATTACH %p411 => @PLACE(287, -406);
//   $JUNCTION @ATTACH %p412 => @PLACE(250, -406);
//   $JUNCTION @ATTACH %p413 => @PLACE(176, -406);
//   $JUNCTION @ATTACH %p414 => @PLACE(213, -406);
//   $JUNCTION @ATTACH %p415 => @PLACE(324, -406);
//   $JUNCTION @ATTACH %p416 => @PLACE(139, -406);
//   $JUNCTION @ATTACH %p417 => @PLACE(103, -406);
//   $JUNCTION @ATTACH %p418 => @PLACE(-25, -406);
//   $JUNCTION @ATTACH %p419 => @PLACE(472, 43);
//   $JUNCTION @ATTACH %p420 => @PLACE(30, -406);
//   $JUNCTION @ATTACH %p421 => @PLACE(8, -438);
//   $JUNCTION @ATTACH %p424 => @PLACE(67, -406);
//   $JUNCTION @ATTACH %p425 => @PLACE(472, 63);
//   $JUNCTION @ATTACH %p427 => @PLACE(504, 75);
//   $JUNCTION @ATTACH %p429 => @PLACE(-4, -406);
//   $JUNCTION @ATTACH %p433 => @PLACE(504, -394);
//   $JUNCTION @ATTACH %p436 => @PLACE(427, 84);
//   $JUNCTION @ATTACH %p438 => @PLACE(7, 116);
//   $JUNCTION @ATTACH %p442 => @PLACE(475, -20);
//   $JUNCTION @ATTACH %p443 => @PLACE(475, 18);
//   $JUNCTION @ATTACH %p444 => @PLACE(475, -58);
//   $JUNCTION @ATTACH %p445 => @PLACE(475, -96);
//   $JUNCTION @ATTACH %p446 => @PLACE(475, -134);
//   $JUNCTION @ATTACH %p447 => @PLACE(475, -171);
//   $JUNCTION @ATTACH %p448 => @PLACE(475, -209);
//   $JUNCTION @ATTACH %p449 => @PLACE(475, -247);
//   $JUNCTION @ATTACH %p450 => @PLACE(475, -285);
//   $JUNCTION @ATTACH %p451 => @PLACE(475, -322);
//   $JUNCTION @ATTACH %p452 => @PLACE(475, -360);
//   $JUNCTION @ATTACH %p453 => @PLACE(475, -387);
//   $JUNCTION @ATTACH %p454 => @PLACE(452, -409);
//   $JUNCTION @ATTACH %p455 => @PLACE(373, -409);
//   $JUNCTION @ATTACH %p456 => @PLACE(411, -409);
//   $JUNCTION @ATTACH %p457 => @PLACE(225, -409);
//   $JUNCTION @ATTACH %p458 => @PLACE(262, -409);
//   $JUNCTION @ATTACH %p459 => @PLACE(299, -409);
//   $JUNCTION @ATTACH %p460 => @PLACE(188, -409);
//   $JUNCTION @ATTACH %p461 => @PLACE(336, -409);
//   $JUNCTION @ATTACH %p462 => @PLACE(151, -409);
//   $JUNCTION @ATTACH %p463 => @PLACE(-13, -409);
//   $JUNCTION @ATTACH %p464 => @PLACE(475, 55);
//   $JUNCTION @ATTACH %p465 => @PLACE(475, 82);
//   $JUNCTION @ATTACH %p466 => @PLACE(422, 87);
//   $JUNCTION @ATTACH %p467 => @PLACE(433, 87);
//   $JUNCTION @ATTACH %p468 => @PLACE(42, -409);
//   $JUNCTION @ATTACH %p469 => @PLACE(115, -409);
//   $JUNCTION @ATTACH %p470 => @PLACE(15, -409);
//   $JUNCTION @ATTACH %p471 => @PLACE(445, 87);
//   $JUNCTION @ATTACH %p475 => @PLACE(432, 116);
//   $JUNCTION @ATTACH %p477 => @PLACE(422, 79);
//   $JUNCTION @ATTACH %p480 => @PLACE(79, -409);
//   (561, 154) @TEXT("DIGITAL", size=16, halign="middle", valign="baseline");
//   (-242, 171) @TEXT("ANALOG", size=16, halign="middle", valign="top");
//   (145, -155) @TEXT("GATE", size=8, halign="middle", valign="baseline");
//   @LINE {(-78, -391) (-78, -482)};
//   @LINE {(121, -162) (127, -168)};
//   @LINE {(169, -162) (163, -156)};
//   @LINE {(-233, -296) (-142, -296)};
//   @LINE {(369, 155) (369, 64)};
//   @ELLIPSE {(-209.6, 112.4) (-194.4, 127.6)};
//   @LINE {(169, -162) (121, -162) (127, -156)};
//   @LINE {(169, -162) (163, -168)}
// }
ends L1_IO_ring
