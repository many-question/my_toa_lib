// RNL cell RISCA_JL/LB_trangate
// @RNL(type="header") {
//   @VERSION("0.4");
//   @USE-PACKAGE(name="rnl-std-all", version="0.4");
//   @USE-PACKAGE(name="rnl-std-fill") {};
//   @USE-PACKAGE(name="eda-symbol", version="0.2", path="eda-symbol.rnl");
//   @USE-PACKAGE(name="eda-style", version="0.2", path="eda-style.rnl");
//   @DEVICE(model="nch*", terminals=["d", "g", "s", "b"], type="nmos");
//   @DEVICE(model="pch*", terminals=["d", "g", "s", "b"], type="pmos")
// }
subckt LB_trangate A B GND N P VDD
    M0 (A P B VDD) pch_mac l=30n w=5u multi=1 nf=10 sd=100n ad=2.5e-13 \
        as=2.75e-13 pd=6u ps=7.1u nrd=0.046570 nrs=0.046570 sa=349.754n \
        sb=349.754n sa1=161.047n sa2=316.499n sa3=575.493n sa4=331.707n \
        sb1=161.047n sb2=316.499n sb3=575.493n spa=100n spa1=100n \
        spa2=100n spa3=100n sap=150.407n sapb=165.494n spba=115.715n \
        spba1=117.043n dfm_flag=0 spmt=1.11111e+15 spomt=0 \
        spomt1=1.11111e+60 spmb=1.11111e+15 spomb=0 spomb1=1.11111e+60
    M1 (B N A GND) nch_mac l=30n w=5u multi=1 nf=10 sd=100n ad=2.5e-13 \
        as=2.75e-13 pd=6u ps=7.1u nrd=0.110293 nrs=0.110293 sa=349.754n \
        sb=349.754n sa1=161.047n sa2=316.499n sa3=575.493n sa4=331.707n \
        sb1=161.047n sb2=316.499n sb3=575.493n spa=100n spa1=100n \
        spa2=100n spa3=100n sap=150.407n sapb=165.494n spba=115.715n \
        spba1=117.043n dfm_flag=0 spmt=1.11111e+15 spomt=0 \
        spomt1=1.11111e+60 spmb=1.11111e+15 spomb=0 spomb1=1.11111e+60
// @RNL(author="rnl-virtuoso") {
//   %symbol_0 = @DEFINE-SYMBOL(box=[-0.1, -2.8, 3.8, 2.8]) {
//     @LINE {(2, 1.5) (4, 1.5) (4, 3)};
//     @LINE {(2, -1.5) (2, 1.5)};
//     @LINE {(3, -1) (4, -1.5) (3, -2)};
//     @LINE {(0, 0) (1.5, 0)};
//     @LINE {(1.5, 1.5) (1.5, -1.5)};
//     @LINE {(2, -1.5) (4, -1.5) (4, -3)};
//     ? @TEXT("${name}", size=0.8, halign="start", valign="baseline", key="name") => @PLACE(5, 3.5);
//     ? @TEXT("${model}", size=0.8, halign="end", valign="baseline", key="model") => @PLACE(3.2, 3.2);
//     (4, -1) @PIN(terminal=4);
//     (4, -3) @PIN(terminal=3);
//     (4, 3) @PIN(terminal=1);
//     (0, 0) @PIN(terminal=2)
//   };
//   #"M1" @SET-SYMBOL %symbol_0;
//   #"M1" @PLACE(-4, 11) => @ORIENT("R270");
//   %symbol_1 = @DEFINE-SYMBOL(box=[-0.1, -2.8, 3.8, 2.8]) {
//     @LINE {(0, 0) (0.7, 0)};
//     @LINE {(1.5, 1.5) (1.5, -1.5)};
//     @LINE {(2, -1.5) (4, -1.5) (4, -3)};
//     @LINE {(2, 1.5) (4, 1.5) (4, 3)};
//     (1.1, 0) @CIRCLE(radius=0.4);
//     @LINE {(3.7, 2) (2.7, 1.5) (3.7, 1)};
//     @LINE {(2, -1.5) (2, 1.5)};
//     ? @TEXT("${name}", size=0.8, halign="start", valign="baseline", key="name") => @PLACE(4.9, 3.4);
//     ? @TEXT("${model}", size=0.8, halign="end", valign="baseline", key="model") => @PLACE(3.3, 3.2);
//     (4, 3) @PIN(terminal=3);
//     (4, 1) @PIN(terminal=4);
//     (0, 0) @PIN(terminal=2);
//     (4, -3) @PIN(terminal=1)
//   };
//   #"M0" @SET-SYMBOL %symbol_1;
//   #"M0" @PLACE(-4, -3) => @ORIENT("MXR90");
//   %port_0 = $IO_PORT @ATTACH &"VDD" => @PLACE(-23, 15) => @ORIENT("R0");
//   %port_1 = $IO_PORT @ATTACH &"GND" => @PLACE(-23, 12) => @ORIENT("R0");
//   %input_port_symbol = @DEFINE-SYMBOL(box=[-2, -1, 0, 1]) {
//       @LINE(fill="linecolor", linestyle="none") {(-2, -0.9) (-2, 0.9) (-0.9, 0.9) (0, 0) (-0.9, -0.9) (-2, -0.9)};
//       %pin = (0, 0) @PIN(terminal="p", direction="right");
//       ? @TEXT("${p}", key="netname", halign="middle") => @PLACE(-1, 1.6)
//     };
//   %port_2 = $IO_PORT @ATTACH &"P" => @PLACE(-6, -7) => @ORIENT("R0");
//   %port_2 @SET-SYMBOL %input_port_symbol;
//   %port_2 @TEXT("P", key="netname");
//   %port_3 = $IO_PORT @ATTACH &"N" => @PLACE(-6, 14) => @ORIENT("R0");
//   %port_3 @SET-SYMBOL %input_port_symbol;
//   %port_3 @TEXT("N", key="netname");
//   %port_4 = $IO_PORT @ATTACH &"A" => @PLACE(-11, 4) => @ORIENT("R0");
//   %port_5 = $IO_PORT @ATTACH &"B" => @PLACE(5, 4) => @ORIENT("R0");
//   %p0 = (-1, 4);
//   %p1 = (3, 4);
//   %wire_0 = &"B" @WIRE(mode="straight") {%p0 %p1};
//   %wire_1 = &"B" @WIRE(mode="straight") {#"M0":3 %p0};
//   %wire_2 = &"B" @WIRE(mode="straight") {%p0 #"M1":1};
//   %p2 = (-7, 4);
//   %wire_3 = &"A" @WIRE(mode="straight") {%port_4::pin %p2};
//   %wire_4 = &"A" @WIRE(mode="straight") {%p2 #"M1":3};
//   %wire_5 = &"A" @WIRE(mode="straight") {#"M0":1 %p2};
//   %p3 = (-7, 14);
//   %p4 = (-4, 14);
//   %wire_6 = &"N" @WIRE(mode="straight") {%p3 %port_3::pin %p4};
//   %wire_7 = &"N" @WIRE(mode="straight") {#"M1":2 %p4};
//   %p5 = (-7, -7);
//   %p6 = (-4, -7);
//   %wire_8 = &"P" @WIRE(mode="straight") {%p5 %port_2::pin %p6};
//   %wire_9 = &"P" @WIRE(mode="straight") {%p6 #"M0":2};
//   %p7 = (-5, 3);
//   %wire_10 = &"GND" @WIRE(mode="straight") {%p7 #"M1":4};
//   %wire_10 @TEXT("GND", size=1, halign="middle", valign="baseline", rotate=90) => @PLACE(-5.7, 5);
//   %p8 = (-3, 5);
//   %wire_11 = &"VDD" @WIRE(mode="straight") {#"M0":4 %p8};
//   %wire_11 @TEXT("VDD", size=1, halign="middle", valign="baseline", rotate=90) => @PLACE(-3.7, 3);
//   $JUNCTION @ATTACH %p0 => @PLACE(-1, 4);
//   $JUNCTION @ATTACH %p2 => @PLACE(-7, 4)
// }
ends LB_trangate
