// RNL cell RISCA_JL/LB_vcmbooster_LV
// @RNL(type="header") {
//   @VERSION("0.4");
//   @USE-PACKAGE(name="rnl-std-all", version="0.4");
//   @USE-PACKAGE(name="rnl-std-fill") {};
//   @USE-PACKAGE(name="eda-symbol", version="0.2", path="eda-symbol.rnl");
//   @USE-PACKAGE(name="eda-style", version="0.2", path="eda-style.rnl");
//   @DEVICE(model="nch*", terminals=["d", "g", "s", "b"], type="nmos");
//   @DEVICE(model="pch*", terminals=["d", "g", "s", "b"], type="pmos");
//   @DEVICE(model="cfmom*", terminals=["p", "n"], type="c")
// }
subckt LB_vcmbooster_LV AVDD AVSS CLK VBTSTP
    C0 (net3 net2) cfmom_2t nr=30 lr=5u w=50n s=50n stm=2 spm=7 multi=1
    M2 (VBTSTP AVDD net2 AVSS) nch_ulvt_mac l=30n w=2u multi=1 nf=4 \
        sd=100n ad=1e-13 as=1.25e-13 pd=2.4u ps=3.5u nrd=0.248269 \
        nrs=0.248269 sa=179.203n sb=179.203n sa1=118.069n sa2=174.76n \
        sa3=310.76n sa4=171.966n sb1=118.069n sb2=174.76n sb3=310.76n \
        spa=100n spa1=100n spa2=100n spa3=100n sap=120.952n sapb=140.537n \
        spba=115.715n spba1=117.043n dfm_flag=0 spmt=1.11111e+15 spomt=0 \
        spomt1=1.11111e+60 spmb=1.11111e+15 spomb=0 spomb1=1.11111e+60
    M4 (VBTSTP AVDD net3 net3) pch_ulvt_mac l=30n w=1u multi=1 nf=2 \
        sd=100n ad=5e-14 as=7.5e-14 pd=1.2u ps=2.3u nrd=0.212518 \
        nrs=0.212518 sa=112.742n sb=112.742n sa1=93.6047n sa2=112.078n \
        sa3=163.715n sa4=110.059n sb1=93.6047n sb2=112.078n sb3=163.715n \
        spa=100n spa1=100n spa2=100n spa3=100n sap=104.359n sapb=125.813n \
        spba=115.715n spba1=117.043n dfm_flag=0 spmt=1.11111e+15 spomt=0 \
        spomt1=1.11111e+60 spmb=1.11111e+15 spomb=0 spomb1=1.11111e+60
    M7 (AVDD VBTSTP net3 net3) pch_ehvt_mac l=30n w=1u multi=1 nf=2 \
        sd=100n ad=5e-14 as=7.5e-14 pd=1.2u ps=2.3u nrd=0.212518 \
        nrs=0.212518 sa=112.742n sb=112.742n sa1=93.6047n sa2=112.078n \
        sa3=163.715n sa4=110.059n sb1=93.6047n sb2=112.078n sb3=163.715n \
        spa=100n spa1=100n spa2=100n spa3=100n sap=104.359n sapb=125.813n \
        spba=115.715n spba1=117.043n dfm_flag=0 spmt=1.11111e+15 spomt=0 \
        spomt1=1.11111e+60 spmb=1.11111e+15 spomb=0 spomb1=1.11111e+60
    M0 (net2 CLK AVDD AVDD) pch_ehvt_mac l=30n w=1u multi=1 nf=2 sd=100n \
        ad=5e-14 as=7.5e-14 pd=1.2u ps=2.3u nrd=0.212518 nrs=0.212518 \
        sa=112.742n sb=112.742n sa1=93.6047n sa2=112.078n sa3=163.715n \
        sa4=110.059n sb1=93.6047n sb2=112.078n sb3=163.715n spa=100n \
        spa1=100n spa2=100n spa3=100n sap=104.359n sapb=125.813n \
        spba=115.715n spba1=117.043n dfm_flag=0 spmt=1.11111e+15 spomt=0 \
        spomt1=1.11111e+60 spmb=1.11111e+15 spomb=0 spomb1=1.11111e+60
    M1 (net2 CLK AVSS AVSS) nch_mac l=30n w=2u multi=1 nf=4 sd=100n \
        ad=1e-13 as=1.25e-13 pd=2.4u ps=3.5u nrd=0.248269 nrs=0.248269 \
        sa=179.203n sb=179.203n sa1=118.069n sa2=174.76n sa3=310.76n \
        sa4=171.966n sb1=118.069n sb2=174.76n sb3=310.76n spa=100n \
        spa1=100n spa2=100n spa3=100n sap=120.952n sapb=140.537n \
        spba=115.715n spba1=117.043n dfm_flag=0 spmt=1.11111e+15 spomt=0 \
        spomt1=1.11111e+60 spmb=1.11111e+15 spomb=0 spomb1=1.11111e+60
// @RNL(author="rnl-virtuoso") {
//   %symbol_0 = @DEFINE-SYMBOL(box=[-0.1, -2.8, 3.8, 2.8]) {
//     @LINE {(2, 1.5) (4, 1.5) (4, 3)};
//     @LINE {(2, -1.5) (2, 1.5)};
//     @LINE {(3, -1) (4, -1.5) (3, -2)};
//     @LINE {(0, 0) (1.5, 0)};
//     @LINE {(1.5, 1.5) (1.5, -1.5)};
//     @LINE {(2, -1.5) (4, -1.5) (4, -3)};
//     ? @TEXT("${name}", size=0.8, halign="start", valign="baseline", key="name") => @PLACE(5, 3.5);
//     ? @TEXT("${model}", size=0.8, halign="end", valign="baseline", key="model") => @PLACE(3.2, 3.2);
//     (4, -1) @PIN(terminal=4);
//     (4, -3) @PIN(terminal=3);
//     (4, 3) @PIN(terminal=1);
//     (0, 0) @PIN(terminal=2)
//   };
//   #"M1" @SET-SYMBOL %symbol_0;
//   #"M1" @PLACE(-4, -8) => @ORIENT("R0");
//   %symbol_1 = @DEFINE-SYMBOL(box=[-2, -6, 2, 0]) {
//     @LINE {(1, -2.2) (-1, -2.2)};
//     @LINE {(0, 0) (0, -2.2)};
//     @LINE {(0, -2.8) (0, -6)};
//     @ARC {(1, -3.2) (0, -2.8) (-1, -3.2)};
//     ? @TEXT("${name}", size=0.8, halign="start", valign="baseline", key="name") => @PLACE(1.4, 0.1);
//     ? @TEXT("${model}", size=0.8, halign="end", valign="baseline", key="model") => @PLACE(-1.1, 0.3);
//     (0, 0) @PIN(terminal=1);
//     (0, -6) @PIN(terminal=2)
//   };
//   #"C0" @SET-SYMBOL %symbol_1;
//   #"C0" @PLACE(43, 19) => @ORIENT("R0");
//   %symbol_2 = @DEFINE-SYMBOL(box=[-0.1, -2.8, 3.8, 2.8]) {
//     @LINE {(0, 0) (0.7, 0)};
//     @LINE {(1.5, 1.5) (1.5, -1.5)};
//     @LINE {(2, -1.5) (4, -1.5) (4, -3)};
//     @LINE {(2, 1.5) (4, 1.5) (4, 3)};
//     (1.1, 0) @CIRCLE(radius=0.4);
//     @LINE {(3.7, 2) (2.7, 1.5) (3.7, 1)};
//     @LINE {(2, -1.5) (2, 1.5)};
//     ? @TEXT("${name}", size=0.8, halign="start", valign="baseline", key="name") => @PLACE(4.9, 3.4);
//     ? @TEXT("${model}", size=0.8, halign="end", valign="baseline", key="model") => @PLACE(3.3, 3.2);
//     (4, 3) @PIN(terminal=3);
//     (4, 1) @PIN(terminal=4);
//     (0, 0) @PIN(terminal=2);
//     (4, -3) @PIN(terminal=1)
//   };
//   #"M0" @SET-SYMBOL %symbol_2;
//   #"M0" @PLACE(-4, 8) => @ORIENT("R0");
//   %symbol_3 = @DEFINE-SYMBOL(box=[-0.1, -2.8, 3.8, 2.8]) {
//     @LINE {(2, 1.5) (4, 1.5) (4, 3)};
//     @LINE {(2, -1.5) (2, 1.5)};
//     @LINE {(3, -1) (4, -1.5) (3, -2)};
//     @LINE {(0, 0) (1.5, 0)};
//     @LINE {(1.5, 1.5) (1.5, -1.5)};
//     @LINE {(2, -1.5) (4, -1.5) (4, -3)};
//     ? @TEXT("${name}", size=0.8, halign="start", valign="baseline", key="name") => @PLACE(5, 3.5);
//     ? @TEXT("${model}", size=0.8, halign="end", valign="baseline", key="model") => @PLACE(3.2, 3.2);
//     (4, -1) @PIN(terminal=4);
//     (4, -3) @PIN(terminal=3);
//     (4, 3) @PIN(terminal=1);
//     (0, 0) @PIN(terminal=2)
//   };
//   #"M2" @SET-SYMBOL %symbol_3;
//   #"M2" @PLACE(59, 4) => @ORIENT("R270");
//   %symbol_4 = @DEFINE-SYMBOL(box=[-0.1, -2.8, 3.8, 2.8]) {
//     @LINE {(0, 0) (0.7, 0)};
//     @LINE {(1.5, 1.5) (1.5, -1.5)};
//     @LINE {(2, -1.5) (4, -1.5) (4, -3)};
//     @LINE {(2, 1.5) (4, 1.5) (4, 3)};
//     (1.1, 0) @CIRCLE(radius=0.4);
//     @LINE {(3.7, 2) (2.7, 1.5) (3.7, 1)};
//     @LINE {(2, -1.5) (2, 1.5)};
//     ? @TEXT("${name}", size=0.8, halign="start", valign="baseline", key="name") => @PLACE(4.9, 3.4);
//     ? @TEXT("${model}", size=0.8, halign="end", valign="baseline", key="model") => @PLACE(3.3, 3.2);
//     (4, 3) @PIN(terminal=3);
//     (4, 1) @PIN(terminal=4);
//     (0, 0) @PIN(terminal=2);
//     (4, -3) @PIN(terminal=1)
//   };
//   #"M4" @SET-SYMBOL %symbol_4;
//   #"M4" @PLACE(59, 28) => @ORIENT("R90");
//   #"M7" @SET-SYMBOL %symbol_2;
//   #"M7" @PLACE(47, 40) => @ORIENT("R180");
//   %port_0 = $IO_PORT @ATTACH &"AVDD" => @PLACE(-2, 40) => @ORIENT("R0");
//   %input_port_symbol = @DEFINE-SYMBOL(box=[-2, -1, 0, 1]) {
//       @LINE(fill="linecolor", linestyle="none") {(-2, -0.9) (-2, 0.9) (-0.9, 0.9) (0, 0) (-0.9, -0.9) (-2, -0.9)};
//       %pin = (0, 0) @PIN(terminal="p", direction="right");
//       ? @TEXT("${p}", key="netname", halign="middle") => @PLACE(-1, 1.6)
//     };
//   %port_1 = $IO_PORT @ATTACH &"CLK" => @PLACE(-11, 0) => @ORIENT("R0");
//   %port_1 @SET-SYMBOL %input_port_symbol;
//   %port_1 @TEXT("CLK", key="netname");
//   %port_2 = $IO_PORT @ATTACH &"AVSS" => @PLACE(-2, 36) => @ORIENT("R0");
//   %output_port_symbol = @DEFINE-SYMBOL(box=[0, -1, 2, 1]) {
//       @LINE(fill="linecolor", linestyle="none") {(0, -0.9) (0, 0.9) (1.1, 0.9) (2, 0) (1.1, -0.9) (0, -0.9)};
//       %pin = (0, 0) @PIN(terminal="p", direction="left");
//       ? @TEXT("${p}", key="netname", halign="middle") => @PLACE(1, 1.6)
//     };
//   %port_3 = $IO_PORT @ATTACH &"VBTSTP" => @PLACE(75, 16) => @ORIENT("R0");
//   %port_3 @SET-SYMBOL %output_port_symbol;
//   %port_3 @TEXT("VBTSTP", key="netname");
//   %p0 = (-6, 0);
//   %p1 = (-6, 8);
//   %wire_0 = &"CLK" @WIRE(mode="straight") {%p0 %p1};
//   %p2 = (-6, -8);
//   %wire_1 = &"CLK" @WIRE(mode="straight") {%p2 %p0};
//   %wire_2 = &"CLK" @WIRE(mode="straight") {%p2 #"M1":2};
//   %wire_3 = &"CLK" @WIRE(mode="straight") {%p1 #"M0":2};
//   %p3 = (-12, 0);
//   %wire_4 = &"CLK" @WIRE(mode="straight") {%p3 %port_1::pin %p0};
//   %p4 = (67, 16);
//   %wire_5 = &"VBTSTP" @WIRE(mode="straight") {%p4 %port_3::pin};
//   %p5 = (67, 0);
//   %wire_6 = &"VBTSTP" @WIRE(mode="straight") {%p5 %p4};
//   %p6 = (67, 32);
//   %wire_7 = &"VBTSTP" @WIRE(mode="straight") {%p4 %p6};
//   %wire_8 = &"VBTSTP" @WIRE(mode="straight") {#"M4":1 %p6};
//   %p7 = (67, 40);
//   %wire_9 = &"VBTSTP" @WIRE(mode="straight") {#"M7":2 %p7};
//   %wire_10 = &"VBTSTP" @WIRE(mode="straight") {#"M2":1 %p5};
//   %wire_11 = &"VBTSTP" @WIRE(mode="straight") {%p6 %p7};
//   %p8 = (56, 33);
//   %p9 = (58, 33);
//   %wire_12 = &"net3" @WIRE(mode="straight") {%p8 %p9};
//   %p10 = (42, 37);
//   %p11 = (42, 39);
//   %wire_13 = &"net3" @WIRE(mode="straight") {%p10 %p11};
//   %wire_14 = &"net3" @WIRE(mode="straight") {%p10 #"M7":3};
//   %wire_15 = &"net3" @WIRE(mode="straight") {%p11 #"M7":4};
//   %wire_16 = &"net3" @WIRE(mode="straight") {#"M4":3 %p8};
//   %wire_17 = &"net3" @WIRE(mode="straight") {#"M4":4 %p9};
//   %p12 = (43, 32);
//   %wire_18 = &"net3" @WIRE(mode="straight") {%p12 #"M4":3};
//   %wire_19 = &"net3" @WIRE(mode="straight") {#"C0":1 %p12};
//   %wire_20 = &"net3" @WIRE(mode="straight") {%p12 #"M7":3};
//   %p13 = (0, 0);
//   %wire_21 = &"net2" @WIRE(mode="straight") {%p13 #"M0":1};
//   %p14 = (43, 0);
//   %wire_22 = &"net2" @WIRE(mode="straight") {%p14 #"C0":2};
//   %wire_23 = &"net2" @WIRE(mode="straight") {%p14 #"M2":3};
//   %wire_24 = &"net2" @WIRE(mode="straight") {#"M1":1 %p13};
//   %wire_25 = &"net2" @WIRE(mode="straight") {%p13 %p14};
//   %p15 = (1, -11);
//   %wire_26 = &"AVSS" @WIRE(mode="straight") {#"M1":3 %p15};
//   %p16 = (1, -9);
//   %wire_27 = &"AVSS" @WIRE(mode="straight") {#"M1":4 %p16};
//   %p17 = (58, -5);
//   %wire_28 = &"AVSS" @WIRE(mode="straight") {%p17 #"M2":4};
//   %wire_29 = &"AVSS" @WIRE(mode="straight") {%p15 %p16};
//   %p18 = (0, -16);
//   %wire_30 = &"AVSS" @WIRE(mode="straight") {%p18 #"M1":3};
//   %wire_28 @TEXT("AVSS", size=1, halign="middle", valign="baseline", rotate=90) => @PLACE(57.3, -3);
//   %wire_30 @TEXT("AVSS", size=1, halign="middle", valign="baseline", rotate=90) => @PLACE(-0.7, -14);
//   %p19 = (1, 11);
//   %wire_31 = &"AVDD" @WIRE(mode="straight") {#"M0":3 %p19};
//   %p20 = (1, 9);
//   %wire_32 = &"AVDD" @WIRE(mode="straight") {%p20 %p19};
//   %wire_33 = &"AVDD" @WIRE(mode="straight") {#"M0":4 %p20};
//   %p21 = (0, 16);
//   %wire_34 = &"AVDD" @WIRE(mode="straight") {#"M0":3 %p21};
//   %p22 = (59, 24);
//   %wire_35 = &"AVDD" @WIRE(mode="straight") {%p22 #"M4":2};
//   %p23 = (43, 48);
//   %wire_36 = &"AVDD" @WIRE(mode="straight") {#"M7":1 %p23};
//   %p24 = (59, 8);
//   %wire_37 = &"AVDD" @WIRE(mode="straight") {%p24 #"M2":2};
//   %wire_37 @TEXT("AVDD", size=1, halign="middle", valign="baseline", rotate=90) => @PLACE(58.3, 6);
//   %wire_36 @TEXT("AVDD", size=1, halign="middle", valign="baseline", rotate=90) => @PLACE(42.3, 47);
//   %wire_34 @TEXT("AVDD", size=1, halign="middle", valign="baseline", rotate=90) => @PLACE(-0.7, 14);
//   %wire_35 @TEXT("AVDD", size=1, halign="middle", valign="baseline", rotate=90) => @PLACE(58.3, 25);
//   $JUNCTION @ATTACH %p0 => @PLACE(-6, 0);
//   $JUNCTION @ATTACH %p4 => @PLACE(67, 16);
//   $JUNCTION @ATTACH %p6 => @PLACE(67, 32);
//   $JUNCTION @ATTACH %p12 => @PLACE(43, 32);
//   $JUNCTION @ATTACH %p13 => @PLACE(0, 0);
//   $JUNCTION @ATTACH %p14 => @PLACE(43, 0)
// }
ends LB_vcmbooster_LV
